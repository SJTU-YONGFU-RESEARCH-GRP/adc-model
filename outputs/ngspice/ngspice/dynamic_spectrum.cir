* Dynamic spectrum testbench for configurable ADC (ngspice behavioral)
* Reference model: veriloga/configurable_adc.va (Spectre AHDL / Python twin)
.param BITS=10
.param VREFP=1.0
.param VREFN=0.0
.param MAXCODE=1023
.param LSB=(1.0-0.0)/1023
.param GAIN=1.01
.param OFFSET_V=0.005
.param SIGMA_THERMAL=0.00025
.param NONLINEARITY_A2=0.0
.param NONLINEARITY_A3=-0.002
.param JITTER_RMS=5e-13
.param DNL_SIGMA_LSB=0.08
.param NOISE_SEED=1
.param VCM=0.5
.param VFS=1.0
.param FS=1000000.0
.param FIN=121704.1015625
.param NUM_SAMPLES=8192
.param DT=1e-06
.param TSTOP=0.008192

.options delmax=1.000000000000e-06 maxstep=1.000000000000e-06

Vin vin 0 PWL(
+ 0.000000000000e+00 5.000000000000e-01
+ 1.000000000000e-06 8.288486371072e-01
+ 2.000000000000e-06 9.745926488943e-01
+ 3.000000000000e-06 8.560810143149e-01
+ 4.000000000000e-06 5.393016256610e-01
+ 5.000000000000e-06 2.006388881677e-01
+ 6.000000000000e-06 2.866196910958e-02
+ 7.000000000000e-06 1.191285082470e-01
+ 8.000000000000e-06 4.216662677673e-01
+ 9.000000000000e-06 7.678206553404e-01
+ 1.000000000000e-05 9.648511141040e-01
+ 1.100000000000e-05 9.030500635555e-01
+ 1.200000000000e-05 6.168286489095e-01
+ 1.300000000000e-05 2.655564371143e-01
+ 1.400000000000e-05 4.482361608119e-02
+ 1.500000000000e-05 7.753536445601e-02
+ 1.600000000000e-05 3.454776112229e-01
+ 1.700000000000e-05 6.994587248360e-01
+ 1.800000000000e-05 9.423801868136e-01
+ 1.900000000000e-05 9.389820682446e-01
+ 2.000000000000e-05 6.911564591582e-01
+ 2.100000000000e-05 3.368939429902e-01
+ 2.200000000000e-05 7.344972462315e-02
+ 2.300000000000e-05 4.751091007993e-02
+ 2.400000000000e-05 2.735203657199e-01
+ 2.500000000000e-05 6.256348554032e-01
+ 2.600000000000e-05 9.077952065256e-01
+ 2.700000000000e-05 9.628930733541e-01
+ 2.800000000000e-05 7.602496781072e-01
+ 2.900000000000e-05 4.126979134089e-01
+ 3.000000000000e-05 1.137564029466e-01
+ 3.100000000000e-05 2.987732893799e-02
+ 3.200000000000e-05 2.077649944742e-01
+ 3.300000000000e-05 5.483706255247e-01
+ 3.400000000000e-05 8.620432416139e-01
+ 3.500000000000e-05 9.741283045706e-01
+ 3.600000000000e-05 8.222162704867e-01
+ 3.700000000000e-05 4.908925471875e-01
+ 3.800000000000e-05 1.646399008116e-01
+ 3.900000000000e-05 2.511749558663e-02
+ 4.000000000000e-05 1.500121297832e-01
+ 4.100000000000e-05 4.697818238444e-01
+ 4.200000000000e-05 8.063771549874e-01
+ 4.300000000000e-05 9.723800985076e-01
+ 4.400000000000e-05 8.753593551827e-01
+ 4.500000000000e-05 5.693365776827e-01
+ 4.600000000000e-05 2.247068344088e-01
+ 4.700000000000e-05 3.336175237661e-02
+ 4.800000000000e-05 1.018432648615e-01
+ 4.900000000000e-05 3.920205108228e-01
+ 5.000000000000e-05 7.423212959357e-01
+ 5.100000000000e-05 9.576963276999e-01
+ 5.200000000000e-05 9.182236722998e-01
+ 5.300000000000e-05 6.458819088197e-01
+ 5.400000000000e-05 2.923123425110e-01
+ 5.500000000000e-05 5.438434018341e-02
+ 5.600000000000e-05 6.457744653750e-02
+ 5.700000000000e-05 3.172160871320e-01
+ 5.800000000000e-05 6.716297576450e-01
+ 5.900000000000e-05 9.304790896714e-01
+ 6.000000000000e-05 9.496354337146e-01
+ 6.100000000000e-05 7.184324381381e-01
+ 6.200000000000e-05 3.656051290329e-01
+ 6.300000000000e-05 8.760958055119e-02
+ 6.400000000000e-05 3.923515473259e-02
+ 6.500000000000e-05 2.474169825617e-01
+ 6.600000000000e-05 5.962383434511e-01
+ 6.700000000000e-05 8.914736959749e-01
+ 6.800000000000e-05 9.687344658617e-01
+ 6.900000000000e-05 7.850014560533e-01
+ 7.000000000000e-05 4.425781585630e-01
+ 7.100000000000e-05 1.321276399597e-01
+ 7.200000000000e-05 2.651035783670e-02
+ 7.300000000000e-05 1.845345622163e-01
+ 7.400000000000e-05 5.182115571774e-01
+ 7.500000000000e-05 8.417482627252e-01
+ 7.600000000000e-05 9.749977645595e-01
+ 7.700000000000e-05 8.437660495256e-01
+ 7.800000000000e-05 5.211236166311e-01
+ 7.900000000000e-05 1.867194445283e-01
+ 8.000000000000e-05 2.675150921318e-02
+ 8.100000000000e-05 1.302907860644e-01
+ 8.200000000000e-05 4.396860691640e-01
+ 8.300000000000e-05 7.826644615154e-01
+ 8.400000000000e-05 9.682538168546e-01
+ 8.500000000000e-05 8.931170203565e-01
+ 8.600000000000e-05 5.990906296897e-01
+ 8.700000000000e-05 2.498900628983e-01
+ 8.800000000000e-05 3.995200521965e-02
+ 8.900000000000e-05 8.617105512261e-02
+ 9.000000000000e-05 3.628122061021e-01
+ 9.100000000000e-05 7.158402316667e-01
+ 9.200000000000e-05 9.486872976992e-01
+ 9.300000000000e-05 9.317029511590e-01
+ 9.400000000000e-05 6.743441642169e-01
+ 9.500000000000e-05 3.199096431422e-01
+ 9.600000000000e-05 6.575036604082e-02
+ 9.700000000000e-05 5.338353552204e-02
+ 9.800000000000e-05 2.896950669068e-01
+ 9.900000000000e-05 6.431054748925e-01
+ 1.000000000000e-04 9.168340128484e-01
+ 1.010000000000e-04 9.584672123085e-01
+ 1.020000000000e-04 7.448234920592e-01
+ 1.030000000000e-04 3.948607826927e-01
+ 1.040000000000e-04 1.034401343815e-01
+ 1.050000000000e-04 3.282607432265e-02
+ 1.060000000000e-04 2.223368770973e-01
+ 1.070000000000e-04 5.664519456264e-01
+ 1.080000000000e-04 8.735662264596e-01
+ 1.090000000000e-04 9.726768964830e-01
+ 1.100000000000e-04 8.085986210106e-01
+ 1.110000000000e-04 4.726910341214e-01
+ 1.120000000000e-04 1.519892209556e-01
+ 1.130000000000e-04 2.506161304373e-02
+ 1.140000000000e-04 1.625821602429e-01
+ 1.150000000000e-04 4.879787092055e-01
+ 1.160000000000e-04 8.200687751799e-01
+ 1.170000000000e-04 9.739428884548e-01
+ 1.180000000000e-04 8.639231453433e-01
+ 1.190000000000e-04 5.512691089605e-01
+ 1.200000000000e-04 2.100681670188e-01
+ 1.210000000000e-04 3.030277218284e-02
+ 1.220000000000e-04 1.120672278883e-01
+ 1.230000000000e-04 4.098346614736e-01
+ 1.240000000000e-04 7.578066228106e-01
+ 1.250000000000e-04 9.622305205460e-01
+ 1.260000000000e-04 9.092820690430e-01
+ 1.270000000000e-04 6.284432404911e-01
+ 1.280000000000e-04 2.760865500077e-01
+ 1.290000000000e-04 4.840602885745e-02
+ 1.300000000000e-04 7.217537111639e-02
+ 1.310000000000e-04 3.341596838358e-01
+ 1.320000000000e-04 6.884847440229e-01
+ 1.330000000000e-04 9.378605219613e-01
+ 1.340000000000e-04 9.434332921649e-01
+ 1.350000000000e-04 7.021001073049e-01
+ 1.360000000000e-04 3.482365353624e-01
+ 1.370000000000e-04 7.887564700768e-02
+ 1.380000000000e-04 4.399898077461e-02
+ 1.390000000000e-04 2.630260451617e-01
+ 1.400000000000e-04 6.140014356631e-01
+ 1.410000000000e-04 9.015002360024e-01
+ 1.420000000000e-04 9.654416242573e-01
+ 1.430000000000e-04 7.702227040866e-01
+ 1.440000000000e-04 4.245423819164e-01
+ 1.450000000000e-04 1.208772525361e-01
+ 1.460000000000e-04 2.830963365602e-02
+ 1.470000000000e-04 1.983816551779e-01
+ 1.480000000000e-04 5.363963341612e-01
+ 1.490000000000e-04 8.541453456683e-01
+ 1.500000000000e-04 9.747043934343e-01
+ 1.510000000000e-04 8.309455748949e-01
+ 1.520000000000e-04 5.029145452084e-01
+ 1.530000000000e-04 1.732606816458e-01
+ 1.540000000000e-04 2.553696379072e-02
+ 1.550000000000e-04 1.419967232873e-01
+ 1.560000000000e-04 4.577945625233e-01
+ 1.570000000000e-04 7.970926080658e-01
+ 1.580000000000e-04 9.709679498264e-01
+ 1.590000000000e-04 8.826058964457e-01
+ 1.600000000000e-04 5.812068971612e-01
+ 1.610000000000e-04 2.345914767021e-01
+ 1.620000000000e-04 3.575689743103e-02
+ 1.630000000000e-04 9.541528349844e-02
+ 1.640000000000e-04 3.803485363767e-01
+ 1.650000000000e-04 7.319043442654e-01
+ 1.660000000000e-04 9.543346114786e-01
+ 1.670000000000e-04 9.237890125409e-01
+ 1.680000000000e-04 6.572754952360e-01
+ 1.690000000000e-04 3.031901671412e-01
+ 1.700000000000e-04 5.868957390183e-02
+ 1.710000000000e-04 5.991291289886e-02
+ 1.720000000000e-04 3.061790226391e-01
+ 1.730000000000e-04 6.603656570045e-01
+ 1.740000000000e-04 9.252598624933e-01
+ 1.750000000000e-04 9.533671727391e-01
+ 1.760000000000e-04 7.290372917376e-01
+ 1.770000000000e-04 3.771782597660e-01
+ 1.780000000000e-04 9.370700925079e-02
+ 1.790000000000e-04 3.646180150028e-02
+ 1.800000000000e-04 2.373170648495e-01
+ 1.810000000000e-04 5.844355477815e-01
+ 1.820000000000e-04 8.845398801419e-01
+ 1.830000000000e-04 9.705304144540e-01
+ 1.840000000000e-04 7.945271755876e-01
+ 1.850000000000e-04 4.545296790378e-01
+ 1.860000000000e-04 1.398502928388e-01
+ 1.870000000000e-04 2.570412997625e-02
+ 1.880000000000e-04 1.756483654670e-01
+ 1.890000000000e-04 5.061932719399e-01
+ 1.900000000000e-04 8.332897325016e-01
+ 1.910000000000e-04 9.748087428126e-01
+ 1.920000000000e-04 8.519517845436e-01
+ 1.930000000000e-04 5.331262487354e-01
+ 1.940000000000e-04 1.958558459625e-01
+ 1.950000000000e-04 2.793448431153e-02
+ 1.960000000000e-04 1.228616481617e-01
+ 1.970000000000e-04 4.277814007441e-01
+ 1.980000000000e-04 7.729128436477e-01
+ 1.990000000000e-04 9.660850009032e-01
+ 2.000000000000e-04 8.997386142825e-01
+ 2.010000000000e-04 6.108156956803e-01
+ 2.020000000000e-04 2.601900234476e-01
+ 2.030000000000e-04 4.309178891678e-02
+ 2.040000000000e-04 8.040241413377e-02
+ 2.050000000000e-04 3.513471496245e-01
+ 2.060000000000e-04 7.050625625619e-01
+ 2.070000000000e-04 9.445980779775e-01
+ 2.080000000000e-04 9.365790795528e-01
+ 2.090000000000e-04 6.854705871672e-01
+ 2.100000000000e-04 3.310911106902e-01
+ 2.110000000000e-04 7.076097911061e-02
+ 2.120000000000e-04 4.943335879003e-02
+ 2.130000000000e-04 2.789835792482e-01
+ 2.140000000000e-04 6.315968881454e-01
+ 2.150000000000e-04 9.109363677540e-01
+ 2.160000000000e-04 9.614643482185e-01
+ 2.170000000000e-04 7.550465881671e-01
+ 2.180000000000e-04 4.066175661067e-01
+ 2.190000000000e-04 1.101843671701e-01
+ 2.200000000000e-04 3.080253271883e-02
+ 2.210000000000e-04 2.126722795525e-01
+ 2.220000000000e-04 5.545275901381e-01
+ 2.230000000000e-04 8.660216559586e-01
+ 2.240000000000e-04 9.737129669224e-01
+ 2.250000000000e-04 8.176384430004e-01
+ 2.260000000000e-04 4.847011879311e-01
+ 2.270000000000e-04 1.602823907041e-01
+ 2.280000000000e-04 2.502011883782e-02
+ 2.290000000000e-04 1.542291062714e-01
+ 2.300000000000e-04 4.759651192075e-01
+ 2.310000000000e-04 8.110838783238e-01
+ 2.320000000000e-04 9.729895218721e-01
+ 2.330000000000e-04 8.715321484878e-01
+ 2.340000000000e-04 5.632037494497e-01
+ 2.350000000000e-04 2.196831751797e-01
+ 2.360000000000e-04 3.224446164410e-02
+ 2.370000000000e-04 1.052544558955e-01
+ 2.380000000000e-04 3.980608147779e-01
+ 2.390000000000e-04 7.476274402673e-01
+ 2.400000000000e-04 9.593138237463e-01
+ 2.410000000000e-04 9.152518898801e-01
+ 2.420000000000e-04 6.399755517857e-01
+ 2.430000000000e-04 2.867601010675e-01
+ 2.440000000000e-04 5.227773113932e-02
+ 2.450000000000e-04 6.708944072554e-02
+ 2.460000000000e-04 3.229479931705e-01
+ 2.470000000000e-04 6.773900205475e-01
+ 2.480000000000e-04 9.330603652026e-01
+ 2.490000000000e-04 9.476004542819e-01
+ 2.500000000000e-04 7.129142908355e-01
+ 2.510000000000e-04 3.596763468749e-01
+ 2.520000000000e-04 8.457134016787e-02
+ 2.530000000000e-04 4.077916411435e-02
+ 2.540000000000e-04 2.526835292833e-01
+ 2.550000000000e-04 6.022949870054e-01
+ 2.560000000000e-04 8.949480658437e-01
+ 2.570000000000e-04 9.676920148971e-01
+ 2.580000000000e-04 7.800226263545e-01
+ 2.590000000000e-04 4.364351883080e-01
+ 2.600000000000e-04 1.282409668209e-01
+ 2.610000000000e-04 2.704410155956e-02
+ 2.620000000000e-04 1.891915315299e-01
+ 2.630000000000e-04 5.243987274344e-01
+ 2.640000000000e-04 8.460205854629e-01
+ 2.650000000000e-04 9.749763883373e-01
+ 2.660000000000e-04 8.394628767348e-01
+ 2.670000000000e-04 5.149346761818e-01
+ 2.680000000000e-04 1.820907705354e-01
+ 2.690000000000e-04 2.626037134285e-02
+ 2.700000000000e-04 1.342106524282e-01
+ 2.710000000000e-04 4.458343378566e-01
+ 2.720000000000e-04 7.876177446671e-01
+ 2.730000000000e-04 9.692541007372e-01
+ 2.740000000000e-04 8.896073417205e-01
+ 2.750000000000e-04 5.930251957877e-01
+ 2.760000000000e-04 2.446461387596e-01
+ 2.770000000000e-04 3.844943498005e-02
+ 2.780000000000e-04 8.924647767825e-02
+ 2.790000000000e-04 3.687532102364e-01
+ 2.800000000000e-04 7.213388354898e-01
+ 2.810000000000e-04 9.506818501073e-01
+ 2.820000000000e-04 9.290828750349e-01
+ 2.830000000000e-04 6.685683315245e-01
+ 2.840000000000e-04 3.141940674564e-01
+ 2.850000000000e-04 6.327750952316e-02
+ 2.860000000000e-04 5.553029749649e-02
+ 2.870000000000e-04 2.952661191809e-01
+ 2.880000000000e-04 6.489988266895e-01
+ 2.890000000000e-04 9.197682153468e-01
+ 2.900000000000e-04 9.568084863513e-01
+ 2.910000000000e-04 7.394954248555e-01
+ 2.920000000000e-04 3.888300696728e-01
+ 2.930000000000e-04 1.000647078077e-01
+ 2.940000000000e-04 3.398538920352e-02
+ 2.950000000000e-04 2.273854208993e-01
+ 2.960000000000e-04 5.725786629977e-01
+ 2.970000000000e-04 8.773597294176e-01
+ 2.980000000000e-04 9.720249429218e-01
+ 2.990000000000e-04 8.038642220516e-01
+ 3.000000000000e-04 4.665103276400e-01
+ 3.010000000000e-04 1.478036563505e-01
+ 3.020000000000e-04 2.520173437779e-02
+ 3.030000000000e-04 1.669699472312e-01
+ 3.040000000000e-04 4.941710193143e-01
+ 3.050000000000e-04 8.246176980505e-01
+ 3.060000000000e-04 9.743155602591e-01
+ 3.070000000000e-04 8.599120604894e-01
+ 3.080000000000e-04 5.451076602816e-01
+ 3.090000000000e-04 2.051870810694e-01
+ 3.100000000000e-04 2.941986291474e-02
+ 3.110000000000e-04 1.156741037573e-01
+ 3.120000000000e-04 4.159229953042e-01
+ 3.130000000000e-04 7.629863987745e-01
+ 3.140000000000e-04 9.636176125435e-01
+ 3.150000000000e-04 9.061041370617e-01
+ 3.160000000000e-04 6.224697735270e-01
+ 3.170000000000e-04 2.706436054224e-01
+ 3.180000000000e-04 4.652426640287e-02
+ 3.190000000000e-04 7.490256587895e-02
+ 3.200000000000e-04 3.399773196387e-01
+ 3.210000000000e-04 6.941535311026e-01
+ 3.220000000000e-04 9.402240502947e-01
+ 3.230000000000e-04 9.411755369276e-01
+ 3.240000000000e-04 6.964781983133e-01
+ 3.250000000000e-04 3.423807806772e-01
+ 3.260000000000e-04 7.604656118369e-02
+ 3.270000000000e-04 4.577181345968e-02
+ 3.280000000000e-04 2.684136739295e-01
+ 3.290000000000e-04 6.200040008957e-01
+ 3.300000000000e-04 9.047754782714e-01
+ 3.310000000000e-04 9.641658716941e-01
+ 3.320000000000e-04 7.651063023298e-01
+ 3.330000000000e-04 4.184341699787e-01
+ 3.340000000000e-04 1.171783144787e-01
+ 3.350000000000e-04 2.907955735816e-02
+ 3.360000000000e-04 2.031917431323e-01
+ 3.370000000000e-04 5.425683044677e-01
+ 3.380000000000e-04 8.582426132755e-01
+ 3.390000000000e-04 9.744455785054e-01
+ 3.400000000000e-04 8.264747869236e-01
+ 3.410000000000e-04 4.967211421058e-01
+ 3.420000000000e-04 1.687931823553e-01
+ 3.430000000000e-04 2.528289506901e-02
+ 3.440000000000e-04 1.460975519153e-01
+ 3.450000000000e-04 4.639669258693e-01
+ 3.460000000000e-04 8.018997022320e-01
+ 3.470000000000e-04 9.717331598695e-01
+ 3.480000000000e-04 8.789031494481e-01
+ 3.490000000000e-04 5.750979018398e-01
+ 3.500000000000e-04 2.294777533102e-01
+ 3.510000000000e-04 3.448579365393e-02
+ 3.520000000000e-04 9.869455650638e-02
+ 3.530000000000e-04 3.863522699649e-01
+ 3.540000000000e-04 7.372896284589e-01
+ 3.550000000000e-04 9.561028921307e-01
+ 3.560000000000e-04 9.209557018207e-01
+ 3.570000000000e-04 6.514181952355e-01
+ 3.580000000000e-04 2.975702528548e-01
+ 3.590000000000e-04 5.643624272796e-02
+ 3.600000000000e-04 6.228083131252e-02
+ 3.610000000000e-04 3.118497213964e-01
+ 3.620000000000e-04 6.661816616503e-01
+ 3.630000000000e-04 9.279827915009e-01
+ 3.640000000000e-04 9.514808851260e-01
+ 3.650000000000e-04 7.235920822221e-01
+ 3.660000000000e-04 3.712060492248e-01
+ 3.670000000000e-04 9.053315546277e-02
+ 3.680000000000e-04 3.785352270235e-02
+ 3.690000000000e-04 2.424994434641e-01
+ 3.700000000000e-04 5.905230085396e-01
+ 3.710000000000e-04 8.881428933466e-01
+ 3.720000000000e-04 9.696428036812e-01
+ 3.730000000000e-04 7.896431671154e-01
+ 3.740000000000e-04 4.483687140938e-01
+ 3.750000000000e-04 1.358428286315e-01
+ 3.760000000000e-04 2.608154334401e-02
+ 3.770000000000e-04 1.802005106908e-01
+ 3.780000000000e-04 5.123854909688e-01
+ 3.790000000000e-04 8.376741656905e-01
+ 3.800000000000e-04 9.749441150408e-01
+ 3.810000000000e-04 8.477627198528e-01
+ 3.820000000000e-04 5.269452400543e-01
+ 3.830000000000e-04 1.911245109563e-01
+ 3.840000000000e-04 2.728725483071e-02
+ 3.850000000000e-04 1.266589049353e-01
+ 3.860000000000e-04 4.339088115222e-01
+ 3.870000000000e-04 7.779586343552e-01
+ 3.880000000000e-04 9.672396491256e-01
+ 3.890000000000e-04 8.963592059059e-01
+ 3.900000000000e-04 6.047839028017e-01
+ 3.910000000000e-04 2.548643796002e-01
+ 3.920000000000e-04 4.143764019360e-02
+ 3.930000000000e-04 8.334079911615e-02
+ 3.940000000000e-04 3.572419603268e-01
+ 3.950000000000e-04 7.106315378366e-01
+ 3.960000000000e-04 9.467403835318e-01
+ 3.970000000000e-04 9.341018685521e-01
+ 3.980000000000e-04 6.797531835342e-01
+ 3.990000000000e-04 3.253169943969e-01
+ 4.000000000000e-04 6.814520803201e-02
+ 4.010000000000e-04 5.143240781834e-02
+ 4.020000000000e-04 2.844843675249e-01
+ 4.030000000000e-04 6.375365482515e-01
+ 4.040000000000e-04 9.140076661616e-01
+ 4.050000000000e-04 9.599571700579e-01
+ 4.060000000000e-04 7.498001380488e-01
+ 4.070000000000e-04 4.005530946451e-01
+ 4.080000000000e-04 1.066786035026e-01
+ 4.090000000000e-04 3.180750422326e-02
+ 4.100000000000e-04 2.176284128873e-01
+ 4.110000000000e-04 5.606752845784e-01
+ 4.120000000000e-04 8.699378433812e-01
+ 4.130000000000e-04 9.732170938756e-01
+ 4.140000000000e-04 8.130066141665e-01
+ 4.150000000000e-04 4.785124296081e-01
+ 4.160000000000e-04 1.559826355981e-01
+ 4.170000000000e-04 2.500349287416e-02
+ 4.180000000000e-04 1.585048668729e-01
+ 4.190000000000e-04 4.821525007131e-01
+ 4.200000000000e-04 8.157377146466e-01
+ 4.210000000000e-04 9.735185328302e-01
+ 4.220000000000e-04 8.676417780383e-01
+ 4.230000000000e-04 5.570601760196e-01
+ 4.240000000000e-04 2.147071722927e-01
+ 4.250000000000e-04 3.120669349451e-02
+ 4.260000000000e-04 1.087327571670e-01
+ 4.270000000000e-04 4.041184492971e-01
+ 4.280000000000e-04 7.528914857416e-01
+ 4.290000000000e-04 9.608532323760e-01
+ 4.300000000000e-04 9.122095109626e-01
+ 4.310000000000e-04 6.340453976687e-01
+ 4.320000000000e-04 2.812441122949e-01
+ 4.330000000000e-04 5.024723884496e-02
+ 4.340000000000e-04 6.967503354154e-02
+ 4.350000000000e-04 3.287099996177e-01
+ 4.360000000000e-04 6.831201255758e-01
+ 4.370000000000e-04 9.355680166374e-01
+ 4.380000000000e-04 9.454893788090e-01
+ 4.390000000000e-04 7.073599462183e-01
+ 4.400000000000e-04 3.537714209803e-01
+ 4.410000000000e-04 8.160372633483e-02
+ 4.420000000000e-04 4.240124510404e-02
+ 4.430000000000e-04 2.579921219946e-01
+ 4.440000000000e-04 6.083342395062e-01
+ 4.450000000000e-04 8.983552910445e-01
+ 4.460000000000e-04 9.665700521490e-01
+ 4.470000000000e-04 7.749961903300e-01
+ 4.480000000000e-04 4.303030246337e-01
+ 4.490000000000e-04 1.244174960092e-01
+ 4.500000000000e-04 2.765825197260e-02
+ 4.510000000000e-04 1.939013410350e-01
+ 4.520000000000e-04 5.305817496917e-01
+ 4.530000000000e-04 8.502340816375e-01
+ 4.540000000000e-04 9.748742619238e-01
+ 4.550000000000e-04 8.351019922495e-01
+ 4.560000000000e-04 5.087431967053e-01
+ 4.570000000000e-04 1.775161439261e-01
+ 4.580000000000e-04 2.584977340378e-02
+ 4.590000000000e-04 1.381927062196e-01
+ 4.600000000000e-04 4.519918151914e-01
+ 4.610000000000e-04 7.925221302556e-01
+ 4.620000000000e-04 9.701746072679e-01
+ 4.630000000000e-04 8.860314263869e-01
+ 4.640000000000e-04 5.869439467787e-01
+ 4.650000000000e-04 2.394456270381e-01
+ 4.660000000000e-04 3.702533242296e-02
+ 4.670000000000e-04 9.239173196939e-02
+ 4.680000000000e-04 3.747165274869e-01
+ 4.690000000000e-04 7.267998097511e-01
+ 4.700000000000e-04 9.525997826106e-01
+ 4.710000000000e-04 9.263898510231e-01
+ 4.720000000000e-04 6.627638407232e-01
+ 4.730000000000e-04 3.085100804243e-01
+ 4.740000000000e-04 6.087889969551e-02
+ 4.750000000000e-04 5.775262325558e-02
+ 4.760000000000e-04 3.008719780275e-01
+ 4.770000000000e-04 6.548668473666e-01
+ 4.780000000000e-04 9.226310535319e-01
+ 4.790000000000e-04 9.550720989070e-01
+ 4.800000000000e-04 7.341266413092e-01
+ 4.810000000000e-04 3.828182565254e-01
+ 4.820000000000e-04 9.675727377449e-02
+ 4.830000000000e-04 3.522393069420e-02
+ 4.840000000000e-04 2.324803115934e-01
+ 4.850000000000e-04 5.786930413538e-01
+ 4.860000000000e-04 8.810890778806e-01
+ 4.870000000000e-04 9.712927409412e-01
+ 4.880000000000e-04 7.990781634846e-01
+ 4.890000000000e-04 4.603353146993e-01
+ 4.900000000000e-04 1.436779682421e-01
+ 4.910000000000e-04 2.542257562077e-02
+ 4.920000000000e-04 1.714143522770e-01
+ 4.930000000000e-04 5.003643204014e-01
+ 4.940000000000e-04 8.291114330383e-01
+ 4.950000000000e-04 9.746075942187e-01
+ 4.960000000000e-04 8.558397873987e-01
+ 4.970000000000e-04 5.389385429011e-01
+ 4.980000000000e-04 2.003561159265e-01
+ 4.990000000000e-04 2.861695643635e-02
+ 5.000000000000e-04 1.193463184315e-01
+ 5.010000000000e-04 4.220256229700e-01
+ 5.020000000000e-04 7.681214647222e-01
+ 5.030000000000e-04 9.649258854422e-01
+ 5.040000000000e-04 9.028571637816e-01
+ 5.050000000000e-04 6.164754856171e-01
+ 5.060000000000e-04 2.652396534549e-01
+ 5.070000000000e-04 4.471959883797e-02
+ 5.080000000000e-04 7.770203096902e-02
+ 5.090000000000e-04 3.458221607140e-01
+ 5.100000000000e-04 6.997893103629e-01
+ 5.110000000000e-04 9.425127366418e-01
+ 5.120000000000e-04 9.388427779429e-01
+ 5.130000000000e-04 6.908228862883e-01
+ 5.140000000000e-04 3.365518226548e-01
+ 5.150000000000e-04 7.328955119789e-02
+ 5.160000000000e-04 4.762186895811e-02
+ 5.170000000000e-04 2.738406744231e-01
+ 5.180000000000e-04 6.259861643856e-01
+ 5.190000000000e-04 9.079819051252e-01
+ 5.200000000000e-04 9.628112068232e-01
+ 5.210000000000e-04 7.599448301544e-01
+ 5.220000000000e-04 4.123398249542e-01
+ 5.230000000000e-04 1.135444594972e-01
+ 5.240000000000e-04 2.992954170497e-02
+ 5.250000000000e-04 2.080522911183e-01
+ 5.260000000000e-04 5.487330377856e-01
+ 5.270000000000e-04 8.622789764667e-01
+ 5.280000000000e-04 9.741061036276e-01
+ 5.290000000000e-04 8.219484953480e-01
+ 5.300000000000e-04 4.905282964381e-01
+ 5.310000000000e-04 1.643819911563e-01
+ 5.320000000000e-04 2.510953245817e-02
+ 5.330000000000e-04 1.502585470928e-01
+ 5.340000000000e-04 4.701454151570e-01
+ 5.350000000000e-04 8.066554707760e-01
+ 5.360000000000e-04 9.724181710988e-01
+ 5.370000000000e-04 8.751359855604e-01
+ 5.380000000000e-04 5.689761392101e-01
+ 5.390000000000e-04 2.244100210954e-01
+ 5.400000000000e-04 3.329383141347e-02
+ 5.410000000000e-04 1.020420549928e-01
+ 5.420000000000e-04 3.923753246733e-01
+ 5.430000000000e-04 7.426345713147e-01
+ 5.440000000000e-04 9.577936312528e-01
+ 5.450000000000e-04 9.180508249042e-01
+ 5.460000000000e-04 6.455351528012e-01
+ 5.470000000000e-04 2.919847534176e-01
+ 5.480000000000e-04 5.425832132003e-02
+ 5.490000000000e-04 6.472316586033e-02
+ 5.500000000000e-04 3.175524073669e-01
+ 5.510000000000e-04 6.719694139423e-01
+ 5.520000000000e-04 9.306329596446e-01
+ 5.530000000000e-04 9.495178417651e-01
+ 5.540000000000e-04 7.181088600729e-01
+ 5.550000000000e-04 3.652557347955e-01
+ 5.560000000000e-04 8.742891466362e-02
+ 5.570000000000e-04 3.932381289730e-02
+ 5.580000000000e-04 2.477255994531e-01
+ 5.590000000000e-04 5.965950795847e-01
+ 5.600000000000e-04 8.916799188229e-01
+ 5.610000000000e-04 9.686753494736e-01
+ 5.620000000000e-04 7.847099167403e-01
+ 5.630000000000e-04 4.422165269254e-01
+ 5.640000000000e-04 1.318972743675e-01
+ 5.650000000000e-04 2.653952704536e-02
+ 5.660000000000e-04 1.848070246593e-01
+ 5.670000000000e-04 5.185756043546e-01
+ 5.680000000000e-04 8.420011912816e-01
+ 5.690000000000e-04 9.749987425643e-01
+ 5.700000000000e-04 8.435145324206e-01
+ 5.710000000000e-04 5.207596504438e-01
+ 5.720000000000e-04 1.864456875180e-01
+ 5.730000000000e-04 2.672039070186e-02
+ 5.740000000000e-04 1.305196330005e-01
+ 5.750000000000e-04 4.400474583875e-01
+ 5.760000000000e-04 7.829571696339e-01
+ 5.770000000000e-04 9.683148624708e-01
+ 5.780000000000e-04 8.929124129550e-01
+ 5.790000000000e-04 5.987342957319e-01
+ 5.800000000000e-04 2.495804109786e-01
+ 5.810000000000e-04 3.986145113160e-02
+ 5.820000000000e-04 8.635001985169e-02
+ 5.830000000000e-04 3.631610411597e-01
+ 5.840000000000e-04 7.161647038850e-01
+ 5.850000000000e-04 9.488067392656e-01
+ 5.860000000000e-04 9.315508563903e-01
+ 5.870000000000e-04 6.740052202685e-01
+ 5.880000000000e-04 3.195725757611e-01
+ 5.890000000000e-04 6.560285609158e-02
+ 5.900000000000e-04 5.350771730882e-02
+ 5.910000000000e-04 2.900217953672e-01
+ 5.920000000000e-04 6.434528259266e-01
+ 5.930000000000e-04 9.170085796003e-01
+ 5.940000000000e-04 9.583717951061e-01
+ 5.950000000000e-04 7.445112196954e-01
+ 5.960000000000e-04 3.945055300378e-01
+ 5.970000000000e-04 1.032397079548e-01
+ 5.980000000000e-04 3.289207259726e-02
+ 5.990000000000e-04 2.226325518918e-01
+ 6.000000000000e-04 5.668126636831e-01
+ 6.010000000000e-04 8.737911380950e-01
+ 6.020000000000e-04 9.726407697331e-01
+ 6.030000000000e-04 8.083215714369e-01
+ 6.040000000000e-04 4.723273243623e-01
+ 6.050000000000e-04 1.517413664898e-01
+ 6.060000000000e-04 2.506762052223e-02
+ 6.070000000000e-04 1.628386846705e-01
+ 6.080000000000e-04 4.883429164516e-01
+ 6.090000000000e-04 8.203378727624e-01
+ 6.100000000000e-04 9.739670414453e-01
+ 6.110000000000e-04 8.636889052314e-01
+ 6.120000000000e-04 5.509069018545e-01
+ 6.130000000000e-04 2.097796717123e-01
+ 6.140000000000e-04 3.024862435761e-02
+ 6.150000000000e-04 1.122775773340e-01
+ 6.160000000000e-04 4.101923845288e-01
+ 6.170000000000e-04 7.581125374244e-01
+ 6.180000000000e-04 9.623142918760e-01
+ 6.190000000000e-04 9.090970527786e-01
+ 6.200000000000e-04 6.280924546472e-01
+ 6.210000000000e-04 2.757653139599e-01
+ 6.220000000000e-04 4.829320850202e-02
+ 6.230000000000e-04 7.233378541184e-02
+ 6.240000000000e-04 3.345011268815e-01
+ 6.250000000000e-04 6.888190985616e-01
+ 6.260000000000e-04 9.380016176531e-01
+ 6.270000000000e-04 9.433025661975e-01
+ 6.280000000000e-04 7.017703485744e-01
+ 6.290000000000e-04 3.478913552388e-01
+ 6.300000000000e-04 7.870724357272e-02
+ 6.310000000000e-04 4.410112193354e-02
+ 6.320000000000e-04 2.633418581879e-01
+ 6.330000000000e-04 6.143550742271e-01
+ 6.340000000000e-04 9.016947923190e-01
+ 6.350000000000e-04 9.653687683612e-01
+ 6.360000000000e-04 7.699230025183e-01
+ 6.370000000000e-04 4.241827100624e-01
+ 6.380000000000e-04 1.206578775485e-01
+ 6.390000000000e-04 2.835270466481e-02
+ 6.400000000000e-04 1.986631900222e-01
+ 6.410000000000e-04 5.367595727807e-01
+ 6.420000000000e-04 8.543880349173e-01
+ 6.430000000000e-04 9.746914026812e-01
+ 6.440000000000e-04 8.306841374585e-01
+ 6.450000000000e-04 5.025502308079e-01
+ 6.460000000000e-04 1.729963424276e-01
+ 6.470000000000e-04 2.551978520124e-02
+ 6.480000000000e-04 1.422362704543e-01
+ 6.490000000000e-04 4.581574543427e-01
+ 6.500000000000e-04 7.973767844920e-01
+ 6.510000000000e-04 9.710151799527e-01
+ 6.520000000000e-04 8.823898822929e-01
+ 6.530000000000e-04 5.808479165291e-01
+ 6.540000000000e-04 2.342894118669e-01
+ 6.550000000000e-04 3.567993965843e-02
+ 6.560000000000e-04 9.560628327498e-02
+ 6.570000000000e-04 3.807011440370e-01
+ 6.580000000000e-04 7.322222260368e-01
+ 6.590000000000e-04 9.544407691436e-01
+ 6.600000000000e-04 9.236243369614e-01
+ 6.610000000000e-04 6.569316786280e-01
+ 6.620000000000e-04 3.028586483739e-01
+ 6.630000000000e-04 5.855494434279e-02
+ 6.640000000000e-04 6.005013498429e-02
+ 6.650000000000e-04 3.065116904007e-01
+ 6.660000000000e-04 6.607085393086e-01
+ 6.670000000000e-04 9.254220406962e-01
+ 6.680000000000e-04 9.532583451768e-01
+ 6.690000000000e-04 7.287180541609e-01
+ 6.700000000000e-04 3.768263653119e-01
+ 6.710000000000e-04 9.351839457498e-02
+ 6.720000000000e-04 3.654148823169e-02
+ 6.730000000000e-04 2.376206830031e-01
+ 6.740000000000e-04 5.847940411960e-01
+ 6.750000000000e-04 8.847536378263e-01
+ 6.760000000000e-04 9.704804150218e-01
+ 6.770000000000e-04 7.942412589818e-01
+ 6.780000000000e-04 4.541670451063e-01
+ 6.790000000000e-04 1.396128580338e-01
+ 6.800000000000e-04 2.572409922768e-02
+ 6.810000000000e-04 1.759146197922e-01
+ 6.820000000000e-04 5.065575595508e-01
+ 6.830000000000e-04 8.335492161686e-01
+ 6.840000000000e-04 9.748189406852e-01
+ 6.850000000000e-04 8.517070183936e-01
+ 6.860000000000e-04 5.327628056234e-01
+ 6.870000000000e-04 1.955760928969e-01
+ 6.880000000000e-04 2.789418924889e-02
+ 6.890000000000e-04 1.230832476017e-01
+ 6.900000000000e-04 4.281415069703e-01
+ 6.910000000000e-04 7.732109476470e-01
+ 6.920000000000e-04 9.661551168240e-01
+ 6.930000000000e-04 8.995417012168e-01
+ 6.940000000000e-04 6.104613958435e-01
+ 6.950000000000e-04 2.598756128249e-01
+ 6.960000000000e-04 4.299233297221e-02
+ 6.970000000000e-04 8.057329045276e-02
+ 6.980000000000e-04 3.516932133871e-01
+ 6.990000000000e-04 7.053911236717e-01
+ 7.000000000000e-04 9.447261919059e-01
+ 7.010000000000e-04 9.364354118005e-01
+ 7.020000000000e-04 6.851351326832e-01
+ 7.030000000000e-04 3.307506522697e-01
+ 7.040000000000e-04 7.060508576637e-02
+ 7.050000000000e-04 4.954883274405e-02
+ 7.060000000000e-04 2.793061240045e-01
+ 7.070000000000e-04 6.319469091121e-01
+ 7.080000000000e-04 9.111189714430e-01
+ 7.090000000000e-04 9.613778599494e-01
+ 7.100000000000e-04 7.547391650564e-01
+ 7.110000000000e-04 4.062603829356e-01
+ 7.120000000000e-04 1.099763053793e-01
+ 7.130000000000e-04 3.085944219160e-02
+ 7.140000000000e-04 2.129624727996e-01
+ 7.150000000000e-04 5.548894860556e-01
+ 7.160000000000e-04 8.662537490243e-01
+ 7.170000000000e-04 9.736860265145e-01
+ 7.180000000000e-04 8.173674696776e-01
+ 7.190000000000e-04 4.843370610438e-01
+ 7.200000000000e-04 1.600278579902e-01
+ 7.210000000000e-04 2.501690543139e-02
+ 7.220000000000e-04 1.544790014139e-01
+ 7.230000000000e-04 4.763289799884e-01
+ 7.240000000000e-04 8.113591051748e-01
+ 7.250000000000e-04 9.730228670563e-01
+ 7.260000000000e-04 8.713050452338e-01
+ 7.270000000000e-04 5.628426500261e-01
+ 7.280000000000e-04 2.193891416171e-01
+ 7.290000000000e-04 3.218121335378e-02
+ 7.300000000000e-04 1.054572098533e-01
+ 7.310000000000e-04 3.984166765294e-01
+ 7.320000000000e-04 7.479382641451e-01
+ 7.330000000000e-04 9.594065414045e-01
+ 7.340000000000e-04 9.150748756461e-01
+ 7.350000000000e-04 6.396273681024e-01
+ 7.360000000000e-04 2.864346184141e-01
+ 7.370000000000e-04 5.215617994398e-02
+ 7.380000000000e-04 6.723950132377e-02
+ 7.390000000000e-04 3.232861110435e-01
+ 7.400000000000e-04 6.777279299114e-01
+ 7.410000000000e-04 9.332099163724e-01
+ 7.420000000000e-04 9.474783763913e-01
+ 7.430000000000e-04 7.125885574865e-01
+ 7.440000000000e-04 3.593283280843e-01
+ 7.450000000000e-04 8.439481460181e-02
+ 7.460000000000e-04 4.087242212278e-02
+ 7.470000000000e-04 2.529946443238e-01
+ 7.480000000000e-04 6.026507286112e-01
+ 7.490000000000e-04 8.951503552451e-01
+ 7.500000000000e-04 9.676282163070e-01
+ 7.510000000000e-04 7.797282631586e-01
+ 7.520000000000e-04 4.360741634592e-01
+ 7.530000000000e-04 1.280143008259e-01
+ 7.540000000000e-04 2.707800321902e-02
+ 7.550000000000e-04 1.894671242241e-01
+ 7.560000000000e-04 5.247625597231e-01
+ 7.570000000000e-04 8.462700736422e-01
+ 7.580000000000e-04 9.749726160961e-01
+ 7.590000000000e-04 8.392079444765e-01
+ 7.600000000000e-04 5.145705315090e-01
+ 7.610000000000e-04 1.818201710889e-01
+ 7.620000000000e-04 2.623398829690e-02
+ 7.630000000000e-04 1.344431759994e-01
+ 7.640000000000e-04 4.461962977156e-01
+ 7.650000000000e-04 7.879075996885e-01
+ 7.660000000000e-04 9.693104581431e-01
+ 7.670000000000e-04 8.893988214151e-01
+ 7.680000000000e-04 5.926679029577e-01
+ 7.690000000000e-04 2.443390159043e-01
+ 7.700000000000e-04 3.836348969687e-02
+ 7.710000000000e-04 8.942956474623e-02
+ 7.720000000000e-04 3.691033858273e-01
+ 7.730000000000e-04 7.216611200198e-01
+ 7.740000000000e-04 9.507967938800e-01
+ 7.750000000000e-04 9.289264767620e-01
+ 7.760000000000e-04 6.682276745748e-01
+ 7.770000000000e-04 3.138588313849e-01
+ 7.780000000000e-04 6.313435551169e-02
+ 7.790000000000e-04 5.565893444054e-02
+ 7.800000000000e-04 2.955949213634e-01
+ 7.810000000000e-04 6.493447153512e-01
+ 7.820000000000e-04 9.199385978885e-01
+ 7.830000000000e-04 9.567084928908e-01
+ 7.840000000000e-04 7.391807322697e-01
+ 7.850000000000e-04 3.884759004244e-01
+ 7.860000000000e-04 9.986826516952e-02
+ 7.870000000000e-04 3.405605345457e-02
+ 7.880000000000e-04 2.276838458184e-01
+ 7.890000000000e-04 5.729386840434e-01
+ 7.900000000000e-04 8.775808850059e-01
+ 7.910000000000e-04 9.719840924751e-01
+ 7.920000000000e-04 8.035841113103e-01
+ 7.930000000000e-04 4.661469237164e-01
+ 7.940000000000e-04 1.475593044326e-01
+ 7.950000000000e-04 2.521249087976e-02
+ 7.960000000000e-04 1.672298228769e-01
+ 7.970000000000e-04 4.945353139975e-01
+ 7.980000000000e-04 8.248835706037e-01
+ 7.990000000000e-04 9.743349714669e-01
+ 8.000000000000e-04 8.596742020906e-01
+ 8.010000000000e-04 5.447449730653e-01
+ 8.020000000000e-04 2.049015111573e-01
+ 8.030000000000e-04 2.937041711365e-02
+ 8.040000000000e-04 1.158883137456e-01
+ 8.050000000000e-04 4.162815878503e-01
+ 8.060000000000e-04 7.632897076904e-01
+ 8.070000000000e-04 9.636967538531e-01
+ 8.080000000000e-04 9.059150444736e-01
+ 8.090000000000e-04 6.221177347743e-01
+ 8.100000000000e-04 2.703246375069e-01
+ 8.110000000000e-04 4.641597231292e-02
+ 8.120000000000e-04 7.506524432507e-02
+ 8.130000000000e-04 3.403203904190e-01
+ 8.140000000000e-04 6.944859706288e-01
+ 8.150000000000e-04 9.403607545157e-01
+ 8.160000000000e-04 9.410403882248e-01
+ 8.170000000000e-04 6.961464481847e-01
+ 8.180000000000e-04 3.420371493137e-01
+ 8.190000000000e-04 7.588238430919e-02
+ 8.200000000000e-04 4.587850560874e-02
+ 8.210000000000e-04 2.687318283606e-01
+ 8.220000000000e-04 6.203564675728e-01
+ 8.230000000000e-04 9.049660019221e-01
+ 8.240000000000e-04 9.640883677624e-01
+ 8.250000000000e-04 7.648039254064e-01
+ 8.260000000000e-04 4.180752851016e-01
+ 8.270000000000e-04 1.169627506073e-01
+ 8.280000000000e-04 2.912734157309e-02
+ 8.290000000000e-04 2.034762689352e-01
+ 8.300000000000e-04 5.429311464169e-01
+ 8.310000000000e-04 8.584817390934e-01
+ 8.320000000000e-04 9.744278416975e-01
+ 8.330000000000e-04 8.262100634363e-01
+ 8.340000000000e-04 4.963568313488e-01
+ 8.350000000000e-04 1.685321344461e-01
+ 8.360000000000e-04 2.527046283616e-02
+ 8.370000000000e-04 1.463406576906e-01
+ 8.380000000000e-04 4.643302070972e-01
+ 8.390000000000e-04 8.021808820423e-01
+ 8.400000000000e-04 9.717756758865e-01
+ 8.410000000000e-04 8.786833285334e-01
+ 8.420000000000e-04 5.747381414177e-01
+ 8.430000000000e-04 2.291783698483e-01
+ 8.440000000000e-04 3.441348541516e-02
+ 8.450000000000e-04 9.888958509280e-02
+ 8.460000000000e-04 3.867060424489e-01
+ 8.470000000000e-04 7.376051624881e-01
+ 8.480000000000e-04 9.562044967224e-01
+ 8.490000000000e-04 9.207868030118e-01
+ 8.500000000000e-04 6.510728367579e-01
+ 8.510000000000e-04 2.972407320987e-01
+ 8.520000000000e-04 5.630603855800e-02
+ 8.530000000000e-04 6.242244208526e-02
+ 8.540000000000e-04 3.121842974997e-01
+ 8.550000000000e-04 6.665229093760e-01
+ 8.560000000000e-04 9.281407023468e-01
+ 8.570000000000e-04 9.513675335149e-01
+ 8.580000000000e-04 7.232705829184e-01
+ 8.590000000000e-04 3.708554147068e-01
+ 8.600000000000e-04 9.034862084728e-02
+ 8.610000000000e-04 3.793783781954e-02
+ 8.620000000000e-04 2.428056612197e-01
+ 8.630000000000e-04 5.908806253004e-01
+ 8.640000000000e-04 8.883527862470e-01
+ 8.650000000000e-04 9.695881032664e-01
+ 8.660000000000e-04 7.893543308599e-01
+ 8.670000000000e-04 4.480065675215e-01
+ 8.680000000000e-04 1.356090168305e-01
+ 8.690000000000e-04 2.610625393686e-02
+ 8.700000000000e-04 1.804699846913e-01
+ 8.710000000000e-04 5.127496838570e-01
+ 8.720000000000e-04 8.379302929790e-01
+ 8.730000000000e-04 9.749495637278e-01
+ 8.740000000000e-04 8.475144560814e-01
+ 8.750000000000e-04 5.265814983789e-01
+ 8.760000000000e-04 1.908478246268e-01
+ 8.770000000000e-04 2.725168422916e-02
+ 8.780000000000e-04 1.268842559570e-01
+ 8.790000000000e-04 4.342696075505e-01
+ 8.800000000000e-04 7.782539822918e-01
+ 8.810000000000e-04 9.673050977087e-01
+ 8.820000000000e-04 8.961583130254e-01
+ 8.830000000000e-04 6.044285266545e-01
+ 8.840000000000e-04 2.545523954667e-01
+ 8.850000000000e-04 4.134276245611e-02
+ 8.860000000000e-04 8.351585619064e-02
+ 8.870000000000e-04 3.575894795270e-01
+ 8.880000000000e-04 7.109580186709e-01
+ 8.890000000000e-04 9.468640397798e-01
+ 8.900000000000e-04 9.339538477740e-01
+ 8.910000000000e-04 6.794159044664e-01
+ 8.920000000000e-04 3.249782557722e-01
+ 8.930000000000e-04 6.799362127206e-02
+ 8.940000000000e-04 5.155237721662e-02
+ 8.950000000000e-04 2.848090934988e-01
+ 8.960000000000e-04 6.378852216958e-01
+ 8.970000000000e-04 9.141861438957e-01
+ 8.980000000000e-04 9.598660747545e-01
+ 8.990000000000e-04 7.494901920449e-01
+ 9.000000000000e-04 4.001968774818e-01
+ 9.010000000000e-04 1.064744587425e-01
+ 9.020000000000e-04 3.186910072670e-02
+ 9.030000000000e-04 2.179214534019e-01
+ 9.040000000000e-04 5.610366026270e-01
+ 9.050000000000e-04 8.701662552019e-01
+ 9.060000000000e-04 9.731854185830e-01
+ 9.070000000000e-04 8.127324887276e-01
+ 9.080000000000e-04 4.781484884878e-01
+ 9.090000000000e-04 1.557315230983e-01
+ 9.100000000000e-04 2.500502973608e-02
+ 9.110000000000e-04 1.587581973638e-01
+ 9.120000000000e-04 4.825165691028e-01
+ 9.130000000000e-04 8.160098057690e-01
+ 9.140000000000e-04 9.735471449384e-01
+ 9.150000000000e-04 8.674109797620e-01
+ 9.160000000000e-04 5.566984770353e-01
+ 9.170000000000e-04 2.144159684691e-01
+ 9.180000000000e-04 3.114812862978e-02
+ 9.190000000000e-04 1.089394404813e-01
+ 9.200000000000e-04 4.044752984499e-01
+ 9.210000000000e-04 7.531998052755e-01
+ 9.220000000000e-04 9.609413483766e-01
+ 9.230000000000e-04 9.120283599841e-01
+ 9.240000000000e-04 6.336958455148e-01
+ 9.250000000000e-04 2.809207914163e-01
+ 9.260000000000e-04 5.013017598244e-02
+ 9.270000000000e-04 6.982940990356e-02
+ 9.280000000000e-04 3.290498576459e-01
+ 9.290000000000e-04 6.834562305588e-01
+ 9.300000000000e-04 9.357132235790e-01
+ 9.310000000000e-04 9.453628357315e-01
+ 9.320000000000e-04 7.070321129631e-01
+ 9.330000000000e-04 3.534248368028e-01
+ 9.340000000000e-04 8.143137110121e-02
+ 9.350000000000e-04 4.249908710151e-02
+ 9.360000000000e-04 2.583056822920e-01
+ 9.370000000000e-04 6.086889261049e-01
+ 9.380000000000e-04 8.985536126084e-01
+ 9.390000000000e-04 9.665015822035e-01
+ 9.400000000000e-04 7.746990532956e-01
+ 9.410000000000e-04 4.299426679511e-01
+ 9.420000000000e-04 1.241945681466e-01
+ 9.430000000000e-04 2.769688031928e-02
+ 9.440000000000e-04 1.941800171273e-01
+ 9.450000000000e-04 5.309453052372e-01
+ 9.460000000000e-04 8.504800870245e-01
+ 9.470000000000e-04 9.748657400779e-01
+ 9.480000000000e-04 8.348436881786e-01
+ 9.490000000000e-04 5.083789354547e-01
+ 9.500000000000e-04 1.772487480478e-01
+ 9.510000000000e-04 2.582813030854e-02
+ 9.520000000000e-04 1.384288668950e-01
+ 9.530000000000e-04 4.523542841495e-01
+ 9.540000000000e-04 7.928090829021e-01
+ 9.550000000000e-04 9.702262668823e-01
+ 9.560000000000e-04 8.858190286280e-01
+ 9.570000000000e-04 5.865857558195e-01
+ 9.580000000000e-04 2.391410854609e-01
+ 9.590000000000e-04 3.694401055612e-02
+ 9.600000000000e-04 9.257891024983e-02
+ 9.610000000000e-04 3.750679840781e-01
+ 9.620000000000e-04 7.271198518018e-01
+ 9.630000000000e-04 9.527102090483e-01
+ 9.640000000000e-04 9.262291758351e-01
+ 9.650000000000e-04 6.624215286869e-01
+ 9.660000000000e-04 3.081767326554e-01
+ 9.670000000000e-04 6.074012595925e-02
+ 9.680000000000e-04 5.788569348748e-02
+ 9.690000000000e-04 3.012027980327e-01
+ 9.700000000000e-04 6.552112148520e-01
+ 9.710000000000e-04 9.227972228969e-01
+ 9.720000000000e-04 9.549675461881e-01
+ 9.730000000000e-04 7.338095820020e-01
+ 9.740000000000e-04 3.824652308954e-01
+ 9.750000000000e-04 9.656484832180e-02
+ 9.760000000000e-04 3.529924890817e-02
+ 9.770000000000e-04 2.327814359022e-01
+ 9.780000000000e-04 5.790523041816e-01
+ 9.790000000000e-04 8.813064398233e-01
+ 9.800000000000e-04 9.712471737425e-01
+ 9.810000000000e-04 7.987950391970e-01
+ 9.820000000000e-04 4.599722783932e-01
+ 9.830000000000e-04 1.434371604141e-01
+ 9.840000000000e-04 2.543807931749e-02
+ 9.850000000000e-04 1.716775349597e-01
+ 9.860000000000e-04 5.007286405884e-01
+ 9.870000000000e-04 8.293740353615e-01
+ 9.880000000000e-04 9.746222603437e-01
+ 9.890000000000e-04 8.555983511510e-01
+ 9.900000000000e-04 5.385754372346e-01
+ 9.910000000000e-04 2.000735199581e-01
+ 9.920000000000e-04 2.857222106562e-02
+ 9.930000000000e-04 1.195643525447e-01
+ 9.940000000000e-04 4.223850240430e-01
+ 9.950000000000e-04 7.684221163751e-01
+ 9.960000000000e-04 9.650003832765e-01
+ 9.970000000000e-04 9.026640270171e-01
+ 9.980000000000e-04 6.161222538053e-01
+ 9.990000000000e-04 2.649230078990e-01
+ 1.000000000000e-03 4.461584942447e-02
+ 1.001000000000e-03 7.786894590906e-02
+ 1.002000000000e-03 3.461668009039e-01
+ 1.003000000000e-03 7.001197783590e-01
+ 1.004000000000e-03 9.426450261513e-01
+ 1.005000000000e-03 9.387032294812e-01
+ 1.006000000000e-03 6.904892011622e-01
+ 1.007000000000e-03 3.362097984718e-01
+ 1.008000000000e-03 7.312962879538e-02
+ 1.009000000000e-03 4.773309395866e-02
+ 1.010000000000e-03 2.741611161701e-01
+ 1.011000000000e-03 6.263373992536e-01
+ 1.012000000000e-03 9.081683637195e-01
+ 1.013000000000e-03 9.627290680323e-01
+ 1.014000000000e-03 7.596398292827e-01
+ 1.015000000000e-03 4.119817880676e-01
+ 1.016000000000e-03 1.133327433897e-01
+ 1.017000000000e-03 2.998203100230e-02
+ 1.018000000000e-03 2.083397595077e-01
+ 1.019000000000e-03 5.490954213782e-01
+ 1.020000000000e-03 8.625144982000e-01
+ 1.021000000000e-03 9.740836237801e-01
+ 1.022000000000e-03 8.216805308152e-01
+ 1.023000000000e-03 4.901640512605e-01
+ 1.024000000000e-03 1.641242789364e-01
+ 1.025000000000e-03 2.510184869554e-02
+ 1.026000000000e-03 1.505051701463e-01
+ 1.027000000000e-03 4.705090240323e-01
+ 1.028000000000e-03 8.069336061670e-01
+ 1.029000000000e-03 9.724559657785e-01
+ 1.030000000000e-03 8.749123952553e-01
+ 1.031000000000e-03 5.686156601607e-01
+ 1.032000000000e-03 2.241133699045e-01
+ 1.033000000000e-03 3.322618500155e-02
+ 1.034000000000e-03 1.022410792325e-01
+ 1.035000000000e-03 3.927302018366e-01
+ 1.036000000000e-03 7.429477039580e-01
+ 1.037000000000e-03 9.578906654976e-01
+ 1.038000000000e-03 9.178777315801e-01
+ 1.039000000000e-03 6.451883111680e-01
+ 1.040000000000e-03 2.916572866943e-01
+ 1.041000000000e-03 5.413256467500e-02
+ 1.042000000000e-03 6.486914124530e-02
+ 1.043000000000e-03 3.178888349311e-01
+ 1.044000000000e-03 6.723089690745e-01
+ 1.045000000000e-03 9.307865762875e-01
+ 1.046000000000e-03 9.493999853759e-01
+ 1.047000000000e-03 7.177851536999e-01
+ 1.048000000000e-03 3.649064198247e-01
+ 1.049000000000e-03 8.724849148099e-02
+ 1.050000000000e-03 3.941274206595e-02
+ 1.051000000000e-03 2.480343647510e-01
+ 1.052000000000e-03 5.969517588940e-01
+ 1.053000000000e-03 8.918859112556e-01
+ 1.054000000000e-03 9.686159573758e-01
+ 1.055000000000e-03 7.844182099398e-01
+ 1.056000000000e-03 4.418549292804e-01
+ 1.057000000000e-03 1.316671253206e-01
+ 1.058000000000e-03 2.656897477862e-02
+ 1.059000000000e-03 1.850796725222e-01
+ 1.060000000000e-03 5.189396406041e-01
+ 1.061000000000e-03 8.422539186476e-01
+ 1.062000000000e-03 9.749994411396e-01
+ 1.063000000000e-03 8.432628132349e-01
+ 1.064000000000e-03 5.203956720441e-01
+ 1.065000000000e-03 1.861721149636e-01
+ 1.066000000000e-03 2.668955060874e-02
+ 1.067000000000e-03 1.307486972923e-01
+ 1.068000000000e-03 4.404088828795e-01
+ 1.069000000000e-03 7.832497112959e-01
+ 1.070000000000e-03 9.683756325894e-01
+ 1.071000000000e-03 8.927075744133e-01
+ 1.072000000000e-03 5.983779036913e-01
+ 1.073000000000e-03 2.492709063743e-01
+ 1.074000000000e-03 3.977116773121e-02
+ 1.075000000000e-03 8.652922792042e-02
+ 1.076000000000e-03 3.635099567162e-01
+ 1.077000000000e-03 7.164890489392e-01
+ 1.078000000000e-03 9.489259168105e-01
+ 1.079000000000e-03 9.313985077513e-01
+ 1.080000000000e-03 6.736661739573e-01
+ 1.081000000000e-03 3.192356145208e-01
+ 1.082000000000e-03 6.545560168702e-02
+ 1.083000000000e-03 5.363216175553e-02
+ 1.084000000000e-03 2.903486473524e-01
+ 1.085000000000e-03 6.438000925711e-01
+ 1.086000000000e-03 9.171829010368e-01
+ 1.087000000000e-03 9.582761082554e-01
+ 1.088000000000e-03 7.441988034918e-01
+ 1.089000000000e-03 3.941503394426e-01
+ 1.090000000000e-03 1.030395149320e-01
+ 1.091000000000e-03 3.295834565942e-02
+ 1.092000000000e-03 2.229283898545e-01
+ 1.093000000000e-03 5.671733424356e-01
+ 1.094000000000e-03 8.740158298387e-01
+ 1.095000000000e-03 9.726043649408e-01
+ 1.096000000000e-03 8.080443404856e-01
+ 1.097000000000e-03 4.719636308824e-01
+ 1.098000000000e-03 1.514937168956e-01
+ 1.099000000000e-03 2.507390739122e-02
+ 1.100000000000e-03 1.630954074415e-01
+ 1.101000000000e-03 4.887071305552e-01
+ 1.102000000000e-03 8.206067818984e-01
+ 1.103000000000e-03 9.739909156131e-01
+ 1.104000000000e-03 8.634544511707e-01
+ 1.105000000000e-03 5.505446648013e-01
+ 1.106000000000e-03 2.094913471349e-01
+ 1.107000000000e-03 3.019475287502e-02
+ 1.108000000000e-03 1.124881548668e-01
+ 1.109000000000e-03 4.105501604155e-01
+ 1.110000000000e-03 7.584183001971e-01
+ 1.111000000000e-03 9.623977912384e-01
+ 1.112000000000e-03 9.089117958530e-01
+ 1.113000000000e-03 6.277415934497e-01
+ 1.114000000000e-03 2.754442098236e-01
+ 1.115000000000e-03 4.818065387405e-02
+ 1.116000000000e-03 7.249245129231e-02
+ 1.117000000000e-03 3.348426672859e-01
+ 1.118000000000e-03 6.891533420227e-01
+ 1.119000000000e-03 9.381424556798e-01
+ 1.120000000000e-03 9.431715794465e-01
+ 1.121000000000e-03 7.014404711475e-01
+ 1.122000000000e-03 3.475462645968e-01
+ 1.123000000000e-03 7.853908797340e-02
+ 1.124000000000e-03 4.420353128605e-02
+ 1.125000000000e-03 2.636578104340e-01
+ 1.126000000000e-03 6.147086455189e-01
+ 1.127000000000e-03 9.018891123288e-01
+ 1.128000000000e-03 9.652956387006e-01
+ 1.129000000000e-03 7.696231421613e-01
+ 1.130000000000e-03 4.238230828097e-01
+ 1.131000000000e-03 1.204387257181e-01
+ 1.132000000000e-03 2.839605313156e-02
+ 1.133000000000e-03 1.989449021352e-01
+ 1.134000000000e-03 5.371227897755e-01
+ 1.135000000000e-03 8.546305156889e-01
+ 1.136000000000e-03 9.746781326795e-01
+ 1.137000000000e-03 8.304225054890e-01
+ 1.138000000000e-03 5.021859149073e-01
+ 1.139000000000e-03 1.727321955772e-01
+ 1.140000000000e-03 2.550288573625e-02
+ 1.141000000000e-03 1.424760280844e-01
+ 1.142000000000e-03 4.585203707770e-01
+ 1.143000000000e-03 7.976607859792e-01
+ 1.144000000000e-03 9.710621329928e-01
+ 1.145000000000e-03 8.821736431900e-01
+ 1.146000000000e-03 5.804888883362e-01
+ 1.147000000000e-03 2.339875033425e-01
+ 1.148000000000e-03 3.560325503337e-02
+ 1.149000000000e-03 9.579752094590e-02
+ 1.150000000000e-03 3.810538218778e-01
+ 1.151000000000e-03 7.325399711980e-01
+ 1.152000000000e-03 9.545466594728e-01
+ 1.153000000000e-03 9.234594121746e-01
+ 1.154000000000e-03 6.565877697011e-01
+ 1.155000000000e-03 3.025272455797e-01
+ 1.156000000000e-03 5.842057447452e-02
+ 1.157000000000e-03 6.018761588091e-02
+ 1.158000000000e-03 3.068444719865e-01
+ 1.159000000000e-03 6.610513270720e-01
+ 1.160000000000e-03 9.255839686342e-01
+ 1.161000000000e-03 9.531492509744e-01
+ 1.162000000000e-03 7.283986820352e-01
+ 1.163000000000e-03 3.764745433177e-01
+ 1.164000000000e-03 9.333001902183e-02
+ 1.165000000000e-03 3.662144760380e-02
+ 1.166000000000e-03 2.379244555077e-01
+ 1.167000000000e-03 5.851524847283e-01
+ 1.168000000000e-03 8.849671691700e-01
+ 1.169000000000e-03 9.704301388181e-01
+ 1.170000000000e-03 7.939551692815e-01
+ 1.171000000000e-03 4.538044381371e-01
+ 1.172000000000e-03 1.393756352353e-01
+ 1.173000000000e-03 2.574434748341e-02
+ 1.174000000000e-03 1.761810647684e-01
+ 1.175000000000e-03 5.069218433041e-01
+ 1.176000000000e-03 8.338085036171e-01
+ 1.177000000000e-03 9.748288592341e-01
+ 1.178000000000e-03 8.514620453433e-01
+ 1.179000000000e-03 5.323993432380e-01
+ 1.180000000000e-03 1.952965189160e-01
+ 1.181000000000e-03 2.785417191393e-02
+ 1.182000000000e-03 1.233050687722e-01
+ 1.183000000000e-03 4.285016554689e-01
+ 1.184000000000e-03 7.735088909234e-01
+ 1.185000000000e-03 9.662249585179e-01
+ 1.186000000000e-03 8.993445531110e-01
+ 1.187000000000e-03 6.101070310250e-01
+ 1.188000000000e-03 2.595613434611e-01
+ 1.189000000000e-03 4.289314587349e-02
+ 1.190000000000e-03 8.074441350967e-02
+ 1.191000000000e-03 3.520393643948e-01
+ 1.192000000000e-03 7.057195639552e-01
+ 1.193000000000e-03 9.448540442133e-01
+ 1.194000000000e-03 9.362914873045e-01
+ 1.195000000000e-03 6.847995692891e-01
+ 1.196000000000e-03 3.304102934142e-01
+ 1.197000000000e-03 7.044944502411e-02
+ 1.198000000000e-03 4.966457168688e-02
+ 1.199000000000e-03 2.796287985893e-01
+ 1.200000000000e-03 6.322968524578e-01
+ 1.201000000000e-03 9.113013332813e-01
+ 1.202000000000e-03 9.612911002636e-01
+ 1.203000000000e-03 7.544315920892e-01
+ 1.204000000000e-03 4.059032549090e-01
+ 1.205000000000e-03 1.097684730293e-01
+ 1.206000000000e-03 3.091662764768e-02
+ 1.207000000000e-03 2.132528349034e-01
+ 1.208000000000e-03 5.552513496831e-01
+ 1.209000000000e-03 8.664856266324e-01
+ 1.210000000000e-03 9.736588074493e-01
+ 1.211000000000e-03 8.170963096558e-01
+ 1.212000000000e-03 4.839729433707e-01
+ 1.213000000000e-03 1.597735252732e-01
+ 1.214000000000e-03 2.501397144529e-02
+ 1.215000000000e-03 1.547290998174e-01
+ 1.216000000000e-03 4.766928546944e-01
+ 1.217000000000e-03 8.116341488613e-01
+ 1.218000000000e-03 9.730559339733e-01
+ 1.219000000000e-03 8.710777235505e-01
+ 1.220000000000e-03 5.624815136339e-01
+ 1.221000000000e-03 2.190952731306e-01
+ 1.222000000000e-03 3.211824026919e-02
+ 1.223000000000e-03 1.056601959104e-01
+ 1.224000000000e-03 3.987725980398e-01
+ 1.225000000000e-03 7.482489421672e-01
+ 1.226000000000e-03 9.594989888056e-01
+ 1.227000000000e-03 9.148976172342e-01
+ 1.228000000000e-03 6.392791022798e-01
+ 1.229000000000e-03 2.861092613957e-01
+ 1.230000000000e-03 5.203489220362e-02
+ 1.231000000000e-03 6.738981650385e-02
+ 1.232000000000e-03 3.236243328728e-01
+ 1.233000000000e-03 6.780657347226e-01
+ 1.234000000000e-03 9.333592126960e-01
+ 1.235000000000e-03 9.473560352606e-01
+ 1.236000000000e-03 7.122626990772e-01
+ 1.237000000000e-03 3.589803920472e-01
+ 1.238000000000e-03 8.421853352558e-02
+ 1.239000000000e-03 4.096595022414e-02
+ 1.240000000000e-03 2.533059046713e-01
+ 1.241000000000e-03 6.030064098302e-01
+ 1.242000000000e-03 8.953524121898e-01
+ 1.243000000000e-03 9.675641426234e-01
+ 1.244000000000e-03 7.794337354058e-01
+ 1.245000000000e-03 4.357131762162e-01
+ 1.246000000000e-03 1.277878536605e-01
+ 1.247000000000e-03 2.711218308631e-02
+ 1.248000000000e-03 1.897428995969e-01
+ 1.249000000000e-03 5.251263774446e-01
+ 1.250000000000e-03 8.465193581198e-01
+ 1.251000000000e-03 9.749685644407e-01
+ 1.252000000000e-03 8.389528126709e-01
+ 1.253000000000e-03 5.142063782646e-01
+ 1.254000000000e-03 1.815497588195e-01
+ 1.255000000000e-03 2.620788395528e-02
+ 1.256000000000e-03 1.346759146183e-01
+ 1.257000000000e-03 4.465582892259e-01
+ 1.258000000000e-03 7.881972853414e-01
+ 1.259000000000e-03 9.693665394657e-01
+ 1.260000000000e-03 8.891900720366e-01
+ 1.261000000000e-03 5.923105556136e-01
+ 1.262000000000e-03 2.440320434479e-01
+ 1.263000000000e-03 3.827781598257e-02
+ 1.264000000000e-03 8.961289334221e-02
+ 1.265000000000e-03 3.694536384212e-01
+ 1.266000000000e-03 7.219832741524e-01
+ 1.267000000000e-03 9.509114724606e-01
+ 1.268000000000e-03 9.287698261627e-01
+ 1.269000000000e-03 6.678869186611e-01
+ 1.270000000000e-03 3.135237048154e-01
+ 1.271000000000e-03 6.299145849700e-02
+ 1.272000000000e-03 5.578783277898e-02
+ 1.273000000000e-03 2.959238437922e-01
+ 1.274000000000e-03 6.496905161574e-01
+ 1.275000000000e-03 9.201087333911e-01
+ 1.276000000000e-03 9.566082307604e-01
+ 1.277000000000e-03 7.388658989801e-01
+ 1.278000000000e-03 3.881217967828e-01
+ 1.279000000000e-03 9.967205791852e-02
+ 1.280000000000e-03 3.412699180845e-02
+ 1.281000000000e-03 2.279824309341e-01
+ 1.282000000000e-03 5.732986621811e-01
+ 1.283000000000e-03 8.778018184731e-01
+ 1.284000000000e-03 9.719429643723e-01
+ 1.285000000000e-03 8.033038219783e-01
+ 1.286000000000e-03 4.657835397077e-01
+ 1.287000000000e-03 1.473151598466e-01
+ 1.288000000000e-03 2.522352668698e-02
+ 1.289000000000e-03 1.674898942828e-01
+ 1.290000000000e-03 4.948996118955e-01
+ 1.291000000000e-03 8.251492520363e-01
+ 1.292000000000e-03 9.743541036356e-01
+ 1.293000000000e-03 8.594361321048e-01
+ 1.294000000000e-03 5.443822595268e-01
+ 1.295000000000e-03 2.046161148439e-01
+ 1.296000000000e-03 2.932124817182e-02
+ 1.297000000000e-03 1.161027496969e-01
+ 1.298000000000e-03 4.166402296457e-01
+ 1.299000000000e-03 7.635928617198e-01
+ 1.300000000000e-03 9.637756223817e-01
+ 1.301000000000e-03 9.057257130961e-01
+ 1.302000000000e-03 6.217656241828e-01
+ 1.303000000000e-03 2.700058047035e-01
+ 1.304000000000e-03 4.630794505476e-02
+ 1.305000000000e-03 7.522817274936e-02
+ 1.306000000000e-03 3.406635551348e-01
+ 1.307000000000e-03 6.948182957439e-01
+ 1.308000000000e-03 9.404971996839e-01
+ 1.309000000000e-03 9.409049800693e-01
+ 1.310000000000e-03 6.958145826682e-01
+ 1.311000000000e-03 3.416936108756e-01
+ 1.312000000000e-03 7.571845693216e-02
+ 1.313000000000e-03 4.598546490577e-02
+ 1.314000000000e-03 2.690501188408e-01
+ 1.315000000000e-03 6.207088634474e-01
+ 1.316000000000e-03 9.051562873419e-01
+ 1.317000000000e-03 9.640105908195e-01
+ 1.318000000000e-03 7.645013927058e-01
+ 1.319000000000e-03 4.177164484187e-01
+ 1.320000000000e-03 1.167474120667e-01
+ 1.321000000000e-03 2.917540279027e-02
+ 1.322000000000e-03 2.037609691753e-01
+ 1.323000000000e-03 5.432939631108e-01
+ 1.324000000000e-03 8.587206540258e-01
+ 1.325000000000e-03 9.744098257958e-01
+ 1.326000000000e-03 8.259451480481e-01
+ 1.327000000000e-03 4.959925227350e-01
+ 1.328000000000e-03 1.682712815308e-01
+ 1.329000000000e-03 2.525830987446e-02
+ 1.330000000000e-03 1.465839715145e-01
+ 1.331000000000e-03 4.646935093087e-01
+ 1.332000000000e-03 8.024618840872e-01
+ 1.333000000000e-03 9.718179143701e-01
+ 1.334000000000e-03 8.784632848490e-01
+ 1.335000000000e-03 5.743783370292e-01
+ 1.336000000000e-03 2.288791457038e-01
+ 1.337000000000e-03 3.434145106893e-02
+ 1.338000000000e-03 9.908484964219e-02
+ 1.339000000000e-03 3.870598815809e-01
+ 1.340000000000e-03 7.379205567403e-01
+ 1.341000000000e-03 9.563058329407e-01
+ 1.342000000000e-03 9.206176566647e-01
+ 1.343000000000e-03 6.507273894081e-01
+ 1.344000000000e-03 2.969113306207e-01
+ 1.345000000000e-03 5.617609540178e-02
+ 1.346000000000e-03 6.256431027362e-02
+ 1.347000000000e-03 3.125189840902e-01
+ 1.348000000000e-03 6.668640591406e-01
+ 1.349000000000e-03 9.282983613287e-01
+ 1.350000000000e-03 9.512539163759e-01
+ 1.351000000000e-03 7.229489522703e-01
+ 1.352000000000e-03 3.705048561614e-01
+ 1.353000000000e-03 9.016432721913e-02
+ 1.354000000000e-03 3.802242475599e-02
+ 1.355000000000e-03 2.431120302762e-01
+ 1.356000000000e-03 5.912381885986e-01
+ 1.357000000000e-03 8.885624506894e-01
+ 1.358000000000e-03 9.695331266050e-01
+ 1.359000000000e-03 7.890653243847e-01
+ 1.360000000000e-03 4.476444515355e-01
+ 1.361000000000e-03 1.353754193913e-01
+ 1.362000000000e-03 2.613124330920e-02
+ 1.363000000000e-03 1.807396466631e-01
+ 1.364000000000e-03 5.131138692450e-01
+ 1.365000000000e-03 8.381862214717e-01
+ 1.366000000000e-03 9.749547330144e-01
+ 1.367000000000e-03 8.472659878762e-01
+ 1.368000000000e-03 5.262177410662e-01
+ 1.369000000000e-03 1.905713201634e-01
+ 1.370000000000e-03 2.721639173328e-02
+ 1.371000000000e-03 1.271098264732e-01
+ 1.372000000000e-03 4.346304422464e-01
+ 1.373000000000e-03 7.785491665387e-01
+ 1.374000000000e-03 9.673702713884e-01
+ 1.375000000000e-03 8.959571870951e-01
+ 1.376000000000e-03 6.040730890746e-01
+ 1.377000000000e-03 2.542405557236e-01
+ 1.378000000000e-03 4.124815453484e-02
+ 1.379000000000e-03 8.369115827203e-02
+ 1.380000000000e-03 3.579370825037e-01
+ 1.381000000000e-03 7.112843754040e-01
+ 1.382000000000e-03 9.469874331492e-01
+ 1.383000000000e-03 9.338055717121e-01
+ 1.384000000000e-03 6.790785198529e-01
+ 1.385000000000e-03 3.246396201083e-01
+ 1.386000000000e-03 6.784228865033e-02
+ 1.387000000000e-03 5.167261042513e-02
+ 1.388000000000e-03 2.851339460638e-01
+ 1.389000000000e-03 6.382338140259e-01
+ 1.390000000000e-03 9.143643779748e-01
+ 1.391000000000e-03 9.597747089238e-01
+ 1.392000000000e-03 7.491800992723e-01
+ 1.393000000000e-03 3.998407190302e-01
+ 1.394000000000e-03 1.062705454834e-01
+ 1.395000000000e-03 3.193097261949e-02
+ 1.396000000000e-03 2.182146598560e-01
+ 1.397000000000e-03 5.613978847694e-01
+ 1.398000000000e-03 8.703944492634e-01
+ 1.399000000000e-03 9.731534649275e-01
+ 1.400000000000e-03 8.124581793162e-01
+ 1.401000000000e-03 4.777845602223e-01
+ 1.402000000000e-03 1.554806131229e-01
+ 1.403000000000e-03 2.500684602531e-02
+ 1.404000000000e-03 1.590117285985e-01
+ 1.405000000000e-03 4.828806477777e-01
+ 1.406000000000e-03 8.162817109910e-01
+ 1.407000000000e-03 9.735754784709e-01
+ 1.408000000000e-03 8.671799653473e-01
+ 1.409000000000e-03 5.563367446966e-01
+ 1.410000000000e-03 2.141249326472e-01
+ 1.411000000000e-03 3.108983957852e-02
+ 1.412000000000e-03 1.091463538464e-01
+ 1.413000000000e-03 4.048322037975e-01
+ 1.414000000000e-03 7.535079758583e-01
+ 1.415000000000e-03 9.610291932172e-01
+ 1.416000000000e-03 9.118469666200e-01
+ 1.417000000000e-03 6.333462147112e-01
+ 1.418000000000e-03 2.805975994164e-01
+ 1.419000000000e-03 5.001337776676e-02
+ 1.420000000000e-03 6.998403932386e-02
+ 1.421000000000e-03 3.293898162396e-01
+ 1.422000000000e-03 6.837922276192e-01
+ 1.423000000000e-03 9.358581742016e-01
+ 1.424000000000e-03 9.452360306585e-01
+ 1.425000000000e-03 7.067041579163e-01
+ 1.426000000000e-03 3.530783388517e-01
+ 1.427000000000e-03 8.125926210069e-02
+ 1.428000000000e-03 4.259719823498e-02
+ 1.429000000000e-03 2.586193847719e-01
+ 1.430000000000e-03 6.090435487647e-01
+ 1.431000000000e-03 8.987516997134e-01
+ 1.432000000000e-03 9.664328378271e-01
+ 1.433000000000e-03 7.744017546628e-01
+ 1.434000000000e-03 4.295823524813e-01
+ 1.435000000000e-03 1.239718613607e-01
+ 1.436000000000e-03 2.773578650973e-02
+ 1.437000000000e-03 1.944588731257e-01
+ 1.438000000000e-03 5.313088425785e-01
+ 1.439000000000e-03 8.507258862331e-01
+ 1.440000000000e-03 9.748569388807e-01
+ 1.441000000000e-03 8.345851871278e-01
+ 1.442000000000e-03 5.080146692750e-01
+ 1.443000000000e-03 1.769815420359e-01
+ 1.444000000000e-03 2.580676615640e-02
+ 1.445000000000e-03 1.386652402733e-01
+ 1.446000000000e-03 4.527167811364e-01
+ 1.447000000000e-03 7.930958632966e-01
+ 1.448000000000e-03 9.702776498746e-01
+ 1.449000000000e-03 8.856064039017e-01
+ 1.450000000000e-03 5.862275139242e-01
+ 1.451000000000e-03 2.388366973402e-01
+ 1.452000000000e-03 3.686296109319e-02
+ 1.453000000000e-03 9.276632820563e-02
+ 1.454000000000e-03 3.754195141636e-01
+ 1.455000000000e-03 7.274397602436e-01
+ 1.456000000000e-03 9.528203691682e-01
+ 1.457000000000e-03 9.260682499075e-01
+ 1.458000000000e-03 6.620791211022e-01
+ 1.459000000000e-03 3.078434977312e-01
+ 1.460000000000e-03 6.060161062824e-02
+ 1.461000000000e-03 5.801902380377e-02
+ 1.462000000000e-03 3.015337349853e-01
+ 1.463000000000e-03 6.555554910306e-01
+ 1.464000000000e-03 9.229631435412e-01
+ 1.465000000000e-03 9.548627258235e-01
+ 1.466000000000e-03 7.334923851507e-01
+ 1.467000000000e-03 3.821122744079e-01
+ 1.468000000000e-03 9.637266019966e-02
+ 1.469000000000e-03 3.537484049362e-02
+ 1.470000000000e-03 2.330827174087e-01
+ 1.471000000000e-03 5.794115205052e-01
+ 1.472000000000e-03 8.815235774533e-01
+ 1.473000000000e-03 9.712013293214e-01
+ 1.474000000000e-03 7.985117391359e-01
+ 1.475000000000e-03 4.596092656345e-01
+ 1.476000000000e-03 1.431965623430e-01
+ 1.477000000000e-03 2.545386218677e-02
+ 1.478000000000e-03 1.719409107861e-01
+ 1.479000000000e-03 5.010929603468e-01
+ 1.480000000000e-03 8.296364439225e-01
+ 1.481000000000e-03 9.746366472607e-01
+ 1.482000000000e-03 8.553567057140e-01
+ 1.483000000000e-03 5.382123088752e-01
+ 1.484000000000e-03 1.997911004287e-01
+ 1.485000000000e-03 2.852776302370e-02
+ 1.486000000000e-03 1.197826104584e-01
+ 1.487000000000e-03 4.227444707750e-01
+ 1.488000000000e-03 7.687226101222e-01
+ 1.489000000000e-03 9.650746075631e-01
+ 1.490000000000e-03 9.024706533758e-01
+ 1.491000000000e-03 6.157689536817e-01
+ 1.492000000000e-03 2.646065006328e-01
+ 1.493000000000e-03 4.451236790176e-02
+ 1.494000000000e-03 7.803610917788e-02
+ 1.495000000000e-03 3.465115315901e-01
+ 1.496000000000e-03 7.004501286299e-01
+ 1.497000000000e-03 9.427770552641e-01
+ 1.498000000000e-03 9.385634229418e-01
+ 1.499000000000e-03 6.901554039763e-01
+ 1.500000000000e-03 3.358678706422e-01
+ 1.501000000000e-03 7.296995750975e-02
+ 1.502000000000e-03 4.784458501620e-02
+ 1.503000000000e-03 2.744816907722e-01
+ 1.504000000000e-03 6.266885598004e-01
+ 1.505000000000e-03 9.083545821989e-01
+ 1.506000000000e-03 9.626466570298e-01
+ 1.507000000000e-03 7.593346756716e-01
+ 1.508000000000e-03 4.116238029599e-01
+ 1.509000000000e-03 1.131212547486e-01
+ 1.510000000000e-03 3.003479679908e-02
+ 1.511000000000e-03 2.086273994733e-01
+ 1.512000000000e-03 5.494577760891e-01
+ 1.513000000000e-03 8.627498066755e-01
+ 1.514000000000e-03 9.740608650415e-01
+ 1.515000000000e-03 8.214123770461e-01
+ 1.516000000000e-03 4.897998118692e-01
+ 1.517000000000e-03 1.638667643036e-01
+ 1.518000000000e-03 2.509444430326e-02
+ 1.519000000000e-03 1.507519987985e-01
+ 1.520000000000e-03 4.708726502563e-01
+ 1.521000000000e-03 8.072115609970e-01
+ 1.522000000000e-03 9.724934825246e-01
+ 1.523000000000e-03 8.746885843988e-01
+ 1.524000000000e-03 5.682551407464e-01
+ 1.525000000000e-03 2.238168810107e-01
+ 1.526000000000e-03 3.315881318063e-02
+ 1.527000000000e-03 1.024403374636e-01
+ 1.528000000000e-03 3.930851421040e-01
+ 1.529000000000e-03 7.432606936815e-01
+ 1.530000000000e-03 9.579874303770e-01
+ 1.531000000000e-03 9.177043924292e-01
+ 1.532000000000e-03 6.448413841244e-01
+ 1.533000000000e-03 2.913299425335e-01
+ 1.534000000000e-03 5.400707032229e-02
+ 1.535000000000e-03 6.501537260654e-02
+ 1.536000000000e-03 3.182253696266e-01
+ 1.537000000000e-03 6.726484228416e-01
+ 1.538000000000e-03 9.309399395097e-01
+ 1.539000000000e-03 9.492818646163e-01
+ 1.540000000000e-03 7.174613192095e-01
+ 1.541000000000e-03 3.645571843260e-01
+ 1.542000000000e-03 8.706831110944e-02
+ 1.543000000000e-03 3.950194218621e-02
+ 1.544000000000e-03 2.483432782739e-01
+ 1.545000000000e-03 5.973083811691e-01
+ 1.546000000000e-03 8.920916731520e-01
+ 1.547000000000e-03 9.685562896033e-01
+ 1.548000000000e-03 7.841263358234e-01
+ 1.549000000000e-03 4.414933658406e-01
+ 1.550000000000e-03 1.314371929544e-01
+ 1.551000000000e-03 2.659870101916e-02
+ 1.552000000000e-03 1.853525056446e-01
+ 1.553000000000e-03 5.193036657120e-01
+ 1.554000000000e-03 8.425064446743e-01
+ 1.555000000000e-03 9.749998602849e-01
+ 1.556000000000e-03 8.430108921165e-01
+ 1.557000000000e-03 5.200316816462e-01
+ 1.558000000000e-03 1.858987270260e-01
+ 1.559000000000e-03 2.665898895196e-02
+ 1.560000000000e-03 1.309779788052e-01
+ 1.561000000000e-03 4.407703424274e-01
+ 1.562000000000e-03 7.835420863295e-01
+ 1.563000000000e-03 9.684361271747e-01
+ 1.564000000000e-03 8.925025048518e-01
+ 1.565000000000e-03 5.980214537775e-01
+ 1.566000000000e-03 2.489615492676e-01
+ 1.567000000000e-03 3.968115507157e-02
+ 1.568000000000e-03 8.670867922333e-02
+ 1.569000000000e-03 3.638589525662e-01
+ 1.570000000000e-03 7.168132666384e-01
+ 1.571000000000e-03 9.490448302638e-01
+ 1.572000000000e-03 9.312459053317e-01
+ 1.573000000000e-03 6.733270254828e-01
+ 1.574000000000e-03 3.188987596196e-01
+ 1.575000000000e-03 6.530860291366e-02
+ 1.576000000000e-03 5.375686878894e-02
+ 1.577000000000e-03 2.906756226701e-01
+ 1.578000000000e-03 6.441472746216e-01
+ 1.579000000000e-03 9.173569770554e-01
+ 1.580000000000e-03 9.581801518127e-01
+ 1.581000000000e-03 7.438862436325e-01
+ 1.582000000000e-03 3.937952111160e-01
+ 1.583000000000e-03 1.028395554308e-01
+ 1.584000000000e-03 3.302489347017e-02
+ 1.585000000000e-03 2.232243908113e-01
+ 1.586000000000e-03 5.675339816717e-01
+ 1.587000000000e-03 8.742403015586e-01
+ 1.588000000000e-03 9.725676821275e-01
+ 1.589000000000e-03 8.077669283197e-01
+ 1.590000000000e-03 4.715999538955e-01
+ 1.591000000000e-03 1.512462723186e-01
+ 1.592000000000e-03 2.508047364698e-02
+ 1.593000000000e-03 1.633523284048e-01
+ 1.594000000000e-03 4.890713513022e-01
+ 1.595000000000e-03 8.208755024297e-01
+ 1.596000000000e-03 9.740145109443e-01
+ 1.597000000000e-03 8.632197832991e-01
+ 1.598000000000e-03 5.501823980139e-01
+ 1.599000000000e-03 2.092031934564e-01
+ 1.600000000000e-03 3.014115776675e-02
+ 1.601000000000e-03 1.126989603628e-01
+ 1.602000000000e-03 4.109079889233e-01
+ 1.603000000000e-03 7.587239109490e-01
+ 1.604000000000e-03 9.624810185841e-01
+ 1.605000000000e-03 9.087262983751e-01
+ 1.606000000000e-03 6.273906571052e-01
+ 1.607000000000e-03 2.751232377878e-01
+ 1.608000000000e-03 4.806836503976e-02
+ 1.609000000000e-03 7.265136866447e-02
+ 1.610000000000e-03 3.351843048481e-01
+ 1.611000000000e-03 6.894874742100e-01
+ 1.612000000000e-03 9.382830359586e-01
+ 1.613000000000e-03 9.430403319891e-01
+ 1.614000000000e-03 7.011104752184e-01
+ 1.615000000000e-03 3.472012636394e-01
+ 1.616000000000e-03 7.837118030864e-02
+ 1.617000000000e-03 4.430620877185e-02
+ 1.618000000000e-03 2.639739017141e-01
+ 1.619000000000e-03 6.150621493305e-01
+ 1.620000000000e-03 9.020831959177e-01
+ 1.621000000000e-03 9.652222353186e-01
+ 1.622000000000e-03 7.693231231920e-01
+ 1.623000000000e-03 4.234635003699e-01
+ 1.624000000000e-03 1.202197971738e-01
+ 1.625000000000e-03 2.843967903075e-02
+ 1.626000000000e-03 1.992267913511e-01
+ 1.627000000000e-03 5.374859849320e-01
+ 1.628000000000e-03 8.548727878405e-01
+ 1.629000000000e-03 9.746645834368e-01
+ 1.630000000000e-03 8.301606791405e-01
+ 1.631000000000e-03 5.018215977207e-01
+ 1.632000000000e-03 1.724682412500e-01
+ 1.633000000000e-03 2.548626540568e-02
+ 1.634000000000e-03 1.427159960366e-01
+ 1.635000000000e-03 4.588833116127e-01
+ 1.636000000000e-03 7.979446123601e-01
+ 1.637000000000e-03 9.711088089193e-01
+ 1.638000000000e-03 8.819571792642e-01
+ 1.639000000000e-03 5.801298127939e-01
+ 1.640000000000e-03 2.336857513063e-01
+ 1.641000000000e-03 3.552684360094e-02
+ 1.642000000000e-03 9.598899639879e-02
+ 1.643000000000e-03 3.814065696915e-01
+ 1.644000000000e-03 7.328575795618e-01
+ 1.645000000000e-03 9.546522824039e-01
+ 1.646000000000e-03 9.232942382775e-01
+ 1.647000000000e-03 6.562437686577e-01
+ 1.648000000000e-03 3.021959589537e-01
+ 1.649000000000e-03 5.828646437602e-02
+ 1.650000000000e-03 6.032535550778e-02
+ 1.651000000000e-03 3.071773672007e-01
+ 1.652000000000e-03 6.613940200931e-01
+ 1.653000000000e-03 9.257456462121e-01
+ 1.654000000000e-03 9.530398901959e-01
+ 1.655000000000e-03 7.280791755485e-01
+ 1.656000000000e-03 3.761227939903e-01
+ 1.657000000000e-03 9.314188270212e-02
+ 1.658000000000e-03 3.670167956957e-02
+ 1.659000000000e-03 2.382283821846e-01
+ 1.660000000000e-03 5.855108781676e-01
+ 1.661000000000e-03 8.851804740474e-01
+ 1.662000000000e-03 9.703795858725e-01
+ 1.663000000000e-03 7.936689066549e-01
+ 1.664000000000e-03 4.534418583435e-01
+ 1.665000000000e-03 1.391386245828e-01
+ 1.666000000000e-03 2.576487473151e-02
+ 1.667000000000e-03 1.764477002390e-01
+ 1.668000000000e-03 5.072861229853e-01
+ 1.669000000000e-03 8.340675946948e-01
+ 1.670000000000e-03 9.748384984534e-01
+ 1.671000000000e-03 8.512168655370e-01
+ 1.672000000000e-03 5.320358617929e-01
+ 1.673000000000e-03 1.950171241842e-01
+ 1.674000000000e-03 2.781443233019e-02
+ 1.675000000000e-03 1.235271115426e-01
+ 1.676000000000e-03 4.288618460282e-01
+ 1.677000000000e-03 7.738066733016e-01
+ 1.678000000000e-03 9.662945259436e-01
+ 1.679000000000e-03 8.991471700811e-01
+ 1.680000000000e-03 6.097526014334e-01
+ 1.681000000000e-03 2.592472155411e-01
+ 1.682000000000e-03 4.279422767894e-02
+ 1.683000000000e-03 8.091578320382e-02
+ 1.684000000000e-03 3.523856024439e-01
+ 1.685000000000e-03 7.060478832192e-01
+ 1.686000000000e-03 9.449816348245e-01
+ 1.687000000000e-03 9.361473061495e-01
+ 1.688000000000e-03 6.844638971821e-01
+ 1.689000000000e-03 3.300700343239e-01
+ 1.690000000000e-03 7.029405697540e-02
+ 1.691000000000e-03 4.978057555049e-02
+ 1.692000000000e-03 2.799516028128e-01
+ 1.693000000000e-03 6.326467179768e-01
+ 1.694000000000e-03 9.114834531616e-01
+ 1.695000000000e-03 9.612040692122e-01
+ 1.696000000000e-03 7.541238694464e-01
+ 1.697000000000e-03 4.055461822372e-01
+ 1.698000000000e-03 1.095608702424e-01
+ 1.699000000000e-03 3.097408905341e-02
+ 1.700000000000e-03 2.135433656933e-01
+ 1.701000000000e-03 5.556131808075e-01
+ 1.702000000000e-03 8.667172886464e-01
+ 1.703000000000e-03 9.736313097428e-01
+ 1.704000000000e-03 8.168249630943e-01
+ 1.705000000000e-03 4.836088351258e-01
+ 1.706000000000e-03 1.595193927026e-01
+ 1.707000000000e-03 2.501131688122e-02
+ 1.708000000000e-03 1.549794013348e-01
+ 1.709000000000e-03 4.770567431114e-01
+ 1.710000000000e-03 8.119090092214e-01
+ 1.711000000000e-03 9.730887226036e-01
+ 1.712000000000e-03 8.708501835718e-01
+ 1.713000000000e-03 5.621203404855e-01
+ 1.714000000000e-03 2.188015698930e-01
+ 1.715000000000e-03 3.205554242741e-02
+ 1.716000000000e-03 1.058634139475e-01
+ 1.717000000000e-03 3.991285790997e-01
+ 1.718000000000e-03 7.485594741509e-01
+ 1.719000000000e-03 9.595911658953e-01
+ 1.720000000000e-03 9.147201147487e-01
+ 1.721000000000e-03 6.389307545230e-01
+ 1.722000000000e-03 2.857840302037e-01
+ 1.723000000000e-03 5.191386798961e-02
+ 1.724000000000e-03 6.754038617736e-02
+ 1.725000000000e-03 3.239626584594e-01
+ 1.726000000000e-03 6.784034347822e-01
+ 1.727000000000e-03 9.335082540856e-01
+ 1.728000000000e-03 9.472334309620e-01
+ 1.729000000000e-03 7.119367157992e-01
+ 1.730000000000e-03 3.586325389684e-01
+ 1.731000000000e-03 8.404249704288e-02
+ 1.732000000000e-03 4.105974836340e-02
+ 1.733000000000e-03 2.536173101425e-01
+ 1.734000000000e-03 6.033620304531e-01
+ 1.735000000000e-03 8.955542365587e-01
+ 1.736000000000e-03 9.674997938838e-01
+ 1.737000000000e-03 7.791390432693e-01
+ 1.738000000000e-03 4.353522267916e-01
+ 1.739000000000e-03 1.275616254579e-01
+ 1.740000000000e-03 2.714664114132e-02
+ 1.741000000000e-03 1.900188574859e-01
+ 1.742000000000e-03 5.254901803849e-01
+ 1.743000000000e-03 8.467684387490e-01
+ 1.744000000000e-03 9.749642333736e-01
+ 1.745000000000e-03 8.386974814681e-01
+ 1.746000000000e-03 5.138422166631e-01
+ 1.747000000000e-03 1.812795338861e-01
+ 1.748000000000e-03 2.618205833336e-02
+ 1.749000000000e-03 1.349088681480e-01
+ 1.750000000000e-03 4.469203121746e-01
+ 1.751000000000e-03 7.884868014552e-01
+ 1.752000000000e-03 9.694223446721e-01
+ 1.753000000000e-03 8.889810937074e-01
+ 1.754000000000e-03 5.919531539656e-01
+ 1.755000000000e-03 2.437252215707e-01
+ 1.756000000000e-03 3.819241388753e-02
+ 1.757000000000e-03 8.979646335836e-02
+ 1.758000000000e-03 3.698039678124e-01
+ 1.759000000000e-03 7.223052976979e-01
+ 1.760000000000e-03 9.510258857816e-01
+ 1.761000000000e-03 9.286129233292e-01
+ 1.762000000000e-03 6.675460639838e-01
+ 1.763000000000e-03 3.131886879451e-01
+ 1.764000000000e-03 6.284881856320e-02
+ 1.765000000000e-03 5.591699243600e-02
+ 1.766000000000e-03 2.962528862736e-01
+ 1.767000000000e-03 6.500362289044e-01
+ 1.768000000000e-03 9.202786217546e-01
+ 1.769000000000e-03 9.565077000191e-01
+ 1.770000000000e-03 7.385509251718e-01
+ 1.771000000000e-03 3.877677589560e-01
+ 1.772000000000e-03 9.947608617016e-02
+ 1.773000000000e-03 3.419820422342e-02
+ 1.774000000000e-03 2.282811760707e-01
+ 1.775000000000e-03 5.736585971991e-01
+ 1.776000000000e-03 8.780225296892e-01
+ 1.777000000000e-03 9.719015586376e-01
+ 1.778000000000e-03 8.030233542205e-01
+ 1.779000000000e-03 4.654201758278e-01
+ 1.780000000000e-03 1.470712227359e-01
+ 1.781000000000e-03 2.523484179296e-02
+ 1.782000000000e-03 1.677501612958e-01
+ 1.783000000000e-03 4.952639127939e-01
+ 1.784000000000e-03 8.254147421920e-01
+ 1.785000000000e-03 9.743729567540e-01
+ 1.786000000000e-03 8.591978506719e-01
+ 1.787000000000e-03 5.440195198792e-01
+ 1.788000000000e-03 2.043308922974e-01
+ 1.789000000000e-03 2.927235611816e-02
+ 1.790000000000e-03 1.163174114850e-01
+ 1.791000000000e-03 4.169989204796e-01
+ 1.792000000000e-03 7.638958606842e-01
+ 1.793000000000e-03 9.638542180832e-01
+ 1.794000000000e-03 9.055361430406e-01
+ 1.795000000000e-03 6.214134419598e-01
+ 1.796000000000e-03 2.696871071998e-01
+ 1.797000000000e-03 4.620018469197e-02
+ 1.798000000000e-03 7.539135105600e-02
+ 1.799000000000e-03 3.410068135840e-01
+ 1.800000000000e-03 6.951505062524e-01
+ 1.801000000000e-03 9.406333857189e-01
+ 1.802000000000e-03 9.407693125408e-01
+ 1.803000000000e-03 6.954826019592e-01
+ 1.804000000000e-03 3.413501655652e-01
+ 1.805000000000e-03 7.555477914900e-02
+ 1.806000000000e-03 4.609269128784e-02
+ 1.807000000000e-03 2.693685451829e-01
+ 1.808000000000e-03 6.210611883121e-01
+ 1.809000000000e-03 9.053463344186e-01
+ 1.810000000000e-03 9.639325409112e-01
+ 1.811000000000e-03 7.641987044057e-01
+ 1.812000000000e-03 4.173576601410e-01
+ 1.813000000000e-03 1.165322989839e-01
+ 1.814000000000e-03 2.922374098142e-02
+ 1.815000000000e-03 2.040458436851e-01
+ 1.816000000000e-03 5.436567543361e-01
+ 1.817000000000e-03 8.589593579321e-01
+ 1.818000000000e-03 9.743915308111e-01
+ 1.819000000000e-03 8.256800409147e-01
+ 1.820000000000e-03 4.956282164786e-01
+ 1.821000000000e-03 1.680106237630e-01
+ 1.822000000000e-03 2.524643619108e-02
+ 1.823000000000e-03 1.468274932440e-01
+ 1.824000000000e-03 4.650568322901e-01
+ 1.825000000000e-03 8.027427082016e-01
+ 1.826000000000e-03 9.718598752953e-01
+ 1.827000000000e-03 8.782430185245e-01
+ 1.828000000000e-03 5.740184888859e-01
+ 1.829000000000e-03 2.285800810526e-01
+ 1.830000000000e-03 3.426969065763e-02
+ 1.831000000000e-03 9.928035003963e-02
+ 1.832000000000e-03 3.874137871525e-01
+ 1.833000000000e-03 7.382358110300e-01
+ 1.834000000000e-03 9.564069007261e-01
+ 1.835000000000e-03 9.204482628792e-01
+ 1.836000000000e-03 6.503818533893e-01
+ 1.837000000000e-03 2.965820486145e-01
+ 1.838000000000e-03 5.604641333566e-02
+ 1.839000000000e-03 6.270643579408e-02
+ 1.840000000000e-03 3.128537809709e-01
+ 1.841000000000e-03 6.672051107434e-01
+ 1.842000000000e-03 9.284557683537e-01
+ 1.843000000000e-03 9.511400337758e-01
+ 1.844000000000e-03 7.226271904671e-01
+ 1.845000000000e-03 3.701543737945e-01
+ 1.846000000000e-03 8.998027468680e-02
+ 1.847000000000e-03 3.810728346193e-02
+ 1.848000000000e-03 2.434185504532e-01
+ 1.849000000000e-03 5.915956982238e-01
+ 1.850000000000e-03 8.887718865506e-01
+ 1.851000000000e-03 9.694778737294e-01
+ 1.852000000000e-03 7.887761478598e-01
+ 1.853000000000e-03 4.472823663489e-01
+ 1.854000000000e-03 1.351420364515e-01
+ 1.855000000000e-03 2.615651144631e-02
+ 1.856000000000e-03 1.810094964477e-01
+ 1.857000000000e-03 5.134780469183e-01
+ 1.858000000000e-03 8.384419510181e-01
+ 1.859000000000e-03 9.749596228972e-01
+ 1.860000000000e-03 8.470173153833e-01
+ 1.861000000000e-03 5.258539683303e-01
+ 1.862000000000e-03 1.902949977290e-01
+ 1.863000000000e-03 2.718137736381e-02
+ 1.864000000000e-03 1.273356163510e-01
+ 1.865000000000e-03 4.349913153974e-01
+ 1.866000000000e-03 7.788441869223e-01
+ 1.867000000000e-03 9.674351701261e-01
+ 1.868000000000e-03 8.957558282335e-01
+ 1.869000000000e-03 6.037175902712e-01
+ 1.870000000000e-03 2.539288605545e-01
+ 1.871000000000e-03 4.115381648545e-02
+ 1.872000000000e-03 8.386670525713e-02
+ 1.873000000000e-03 3.582847690522e-01
+ 1.874000000000e-03 7.116106078441e-01
+ 1.875000000000e-03 9.471105635673e-01
+ 1.876000000000e-03 9.336570404536e-01
+ 1.877000000000e-03 6.787410298920e-01
+ 1.878000000000e-03 3.243010876043e-01
+ 1.879000000000e-03 6.769121025587e-02
+ 1.880000000000e-03 5.179310737304e-02
+ 1.881000000000e-03 2.854589250292e-01
+ 1.882000000000e-03 6.385823250365e-01
+ 1.883000000000e-03 9.145423682940e-01
+ 1.884000000000e-03 9.596830726194e-01
+ 1.885000000000e-03 7.488698599135e-01
+ 1.886000000000e-03 3.994846194998e-01
+ 1.887000000000e-03 1.060668638452e-01
+ 1.888000000000e-03 3.199311986524e-02
+ 1.889000000000e-03 2.185080320772e-01
+ 1.890000000000e-03 5.617591307930e-01
+ 1.891000000000e-03 8.706224254313e-01
+ 1.892000000000e-03 9.731212329281e-01
+ 1.893000000000e-03 8.121836860937e-01
+ 1.894000000000e-03 4.774206450256e-01
+ 1.895000000000e-03 1.552299058192e-01
+ 1.896000000000e-03 2.500894174076e-02
+ 1.897000000000e-03 1.592654604278e-01
+ 1.898000000000e-03 4.832447365233e-01
+ 1.899000000000e-03 8.165534301527e-01
+ 1.900000000000e-03 9.736035334112e-01
+ 1.901000000000e-03 8.669487349302e-01
+ 1.902000000000e-03 5.559749792166e-01
+ 1.903000000000e-03 2.138340649983e-01
+ 1.904000000000e-03 3.103182637503e-02
+ 1.905000000000e-03 1.093534971407e-01
+ 1.906000000000e-03 4.051891651299e-01
+ 1.907000000000e-03 7.538159973090e-01
+ 1.908000000000e-03 9.611167668462e-01
+ 1.909000000000e-03 9.116653309769e-01
+ 1.910000000000e-03 6.329965054633e-01
+ 1.911000000000e-03 2.802745364852e-01
+ 1.912000000000e-03 4.989684426662e-02
+ 1.913000000000e-03 7.013892171149e-02
+ 1.914000000000e-03 3.297298751989e-01
+ 1.915000000000e-03 6.841281165595e-01
+ 1.916000000000e-03 9.360028684201e-01
+ 1.917000000000e-03 9.451089636646e-01
+ 1.918000000000e-03 7.063760812706e-01
+ 1.919000000000e-03 3.527319273309e-01
+ 1.920000000000e-03 8.108739943460e-02
+ 1.921000000000e-03 4.269557844675e-02
+ 1.922000000000e-03 2.589332292498e-01
+ 1.923000000000e-03 6.093981072770e-01
+ 1.924000000000e-03 8.989495522431e-01
+ 1.925000000000e-03 9.663638190602e-01
+ 1.926000000000e-03 7.741042946065e-01
+ 1.927000000000e-03 4.292220784365e-01
+ 1.928000000000e-03 1.237493757825e-01
+ 1.929000000000e-03 2.777497052105e-02
+ 1.930000000000e-03 1.947379088659e-01
+ 1.931000000000e-03 5.316723615016e-01
+ 1.932000000000e-03 8.509714791187e-01
+ 1.933000000000e-03 9.748478583374e-01
+ 1.934000000000e-03 8.343264892492e-01
+ 1.935000000000e-03 5.076503983805e-01
+ 1.936000000000e-03 1.767145260472e-01
+ 1.937000000000e-03 2.578568095993e-02
+ 1.938000000000e-03 1.389018262156e-01
+ 1.939000000000e-03 4.530793059388e-01
+ 1.940000000000e-03 7.933824712704e-01
+ 1.941000000000e-03 9.703287562147e-01
+ 1.942000000000e-03 8.853935523332e-01
+ 1.943000000000e-03 5.858692213033e-01
+ 1.944000000000e-03 2.385324628552e-01
+ 1.945000000000e-03 3.678218408186e-02
+ 1.946000000000e-03 9.295398572646e-02
+ 1.947000000000e-03 3.757711175366e-01
+ 1.948000000000e-03 7.277595348884e-01
+ 1.949000000000e-03 9.529302629056e-01
+ 1.950000000000e-03 9.259070733349e-01
+ 1.951000000000e-03 6.617366181705e-01
+ 1.952000000000e-03 3.075103758477e-01
+ 1.953000000000e-03 6.046335378402e-02
+ 1.954000000000e-03 5.815261412619e-02
+ 1.955000000000e-03 3.018647886905e-01
+ 1.956000000000e-03 6.558996756999e-01
+ 1.957000000000e-03 9.231288153672e-01
+ 1.958000000000e-03 9.547576378748e-01
+ 1.959000000000e-03 7.331750509418e-01
+ 1.960000000000e-03 3.817593872709e-01
+ 1.961000000000e-03 9.618070952098e-02
+ 1.962000000000e-03 3.545070540606e-02
+ 1.963000000000e-03 2.333841559358e-01
+ 1.964000000000e-03 5.797706901130e-01
+ 1.965000000000e-03 8.817404906427e-01
+ 1.966000000000e-03 9.711552077045e-01
+ 1.967000000000e-03 7.982282634681e-01
+ 1.968000000000e-03 4.592462766366e-01
+ 1.969000000000e-03 1.429561741700e-01
+ 1.970000000000e-03 2.546992421931e-02
+ 1.971000000000e-03 1.722044796012e-01
+ 1.972000000000e-03 5.014572794623e-01
+ 1.973000000000e-03 8.298986585669e-01
+ 1.974000000000e-03 9.746507549611e-01
+ 1.975000000000e-03 8.551148512298e-01
+ 1.976000000000e-03 5.378491580365e-01
+ 1.977000000000e-03 1.995088575044e-01
+ 1.978000000000e-03 2.848358233678e-02
+ 1.979000000000e-03 1.200010920443e-01
+ 1.980000000000e-03 4.231039629543e-01
+ 1.981000000000e-03 7.690229457867e-01
+ 1.982000000000e-03 9.651485582583e-01
+ 1.983000000000e-03 9.022770429714e-01
+ 1.984000000000e-03 6.154155854541e-01
+ 1.985000000000e-03 2.642901318426e-01
+ 1.986000000000e-03 4.440915433065e-02
+ 1.987000000000e-03 7.820352067724e-02
+ 1.988000000000e-03 3.468563525694e-01
+ 1.989000000000e-03 7.007803609809e-01
+ 1.990000000000e-03 9.429088239025e-01
+ 1.991000000000e-03 9.384233584068e-01
+ 1.992000000000e-03 6.898214949268e-01
+ 1.993000000000e-03 3.355260393673e-01
+ 1.994000000000e-03 7.281053743485e-02
+ 1.995000000000e-03 4.795634206513e-02
+ 1.996000000000e-03 2.748023980409e-01
+ 1.997000000000e-03 6.270396458199e-01
+ 1.998000000000e-03 9.085405604539e-01
+ 1.999000000000e-03 9.625639738642e-01
+ 2.000000000000e-03 7.590293695005e-01
+ 2.001000000000e-03 4.112658698417e-01
+ 2.002000000000e-03 1.129099936982e-01
+ 2.003000000000e-03 3.008783906429e-02
+ 2.004000000000e-03 2.089152108459e-01
+ 2.005000000000e-03 5.498201017054e-01
+ 2.006000000000e-03 8.629849017546e-01
+ 2.007000000000e-03 9.740378274250e-01
+ 2.008000000000e-03 8.211440341984e-01
+ 2.009000000000e-03 4.894355784784e-01
+ 2.010000000000e-03 1.636094474093e-01
+ 2.011000000000e-03 2.508731928568e-02
+ 2.012000000000e-03 1.509990329044e-01
+ 2.013000000000e-03 4.712362936153e-01
+ 2.014000000000e-03 8.074893351022e-01
+ 2.015000000000e-03 9.725307213149e-01
+ 2.016000000000e-03 8.744645531227e-01
+ 2.017000000000e-03 5.678945811795e-01
+ 2.018000000000e-03 2.235205545883e-01
+ 2.019000000000e-03 3.309171599035e-02
+ 2.020000000000e-03 1.026398295688e-01
+ 2.021000000000e-03 3.934401452666e-01
+ 2.022000000000e-03 7.435735403009e-01
+ 2.023000000000e-03 9.580839258344e-01
+ 2.024000000000e-03 9.175308075537e-01
+ 2.025000000000e-03 6.444943718743e-01
+ 2.026000000000e-03 2.910027211280e-01
+ 2.027000000000e-03 5.388183833576e-02
+ 2.028000000000e-03 6.516185985800e-02
+ 2.029000000000e-03 3.185620112553e-01
+ 2.030000000000e-03 6.729877750444e-01
+ 2.031000000000e-03 9.310930492211e-01
+ 2.032000000000e-03 9.491634795558e-01
+ 2.033000000000e-03 7.171373567922e-01
+ 2.034000000000e-03 3.642080285048e-01
+ 2.035000000000e-03 8.688837365500e-02
+ 2.036000000000e-03 3.959141320563e-02
+ 2.037000000000e-03 2.486523398399e-01
+ 2.038000000000e-03 5.976649462001e-01
+ 2.039000000000e-03 8.922972043910e-01
+ 2.040000000000e-03 9.684963461912e-01
+ 2.041000000000e-03 7.838342945627e-01
+ 2.042000000000e-03 4.411318368188e-01
+ 2.043000000000e-03 1.312074774043e-01
+ 2.044000000000e-03 2.662870574947e-02
+ 2.045000000000e-03 1.856255238661e-01
+ 2.046000000000e-03 5.196676794640e-01
+ 2.047000000000e-03 8.427587692133e-01
+ 2.048000000000e-03 9.750000000000e-01
+ 2.049000000000e-03 8.427587692135e-01
+ 2.050000000000e-03 5.196676794642e-01
+ 2.051000000000e-03 1.856255238662e-01
+ 2.052000000000e-03 2.662870574949e-02
+ 2.053000000000e-03 1.312074774041e-01
+ 2.054000000000e-03 4.411318368185e-01
+ 2.055000000000e-03 7.838342945625e-01
+ 2.056000000000e-03 9.684963461912e-01
+ 2.057000000000e-03 8.922972043911e-01
+ 2.058000000000e-03 5.976649462003e-01
+ 2.059000000000e-03 2.486523398401e-01
+ 2.060000000000e-03 3.959141320567e-02
+ 2.061000000000e-03 8.688837365485e-02
+ 2.062000000000e-03 3.642080285046e-01
+ 2.063000000000e-03 7.171373567920e-01
+ 2.064000000000e-03 9.491634795557e-01
+ 2.065000000000e-03 9.310930492212e-01
+ 2.066000000000e-03 6.729877750446e-01
+ 2.067000000000e-03 3.185620112555e-01
+ 2.068000000000e-03 6.516185985812e-02
+ 2.069000000000e-03 5.388183833569e-02
+ 2.070000000000e-03 2.910027211278e-01
+ 2.071000000000e-03 6.444943718741e-01
+ 2.072000000000e-03 9.175308075536e-01
+ 2.073000000000e-03 9.580839258344e-01
+ 2.074000000000e-03 7.435735403010e-01
+ 2.075000000000e-03 3.934401452669e-01
+ 2.076000000000e-03 1.026398295690e-01
+ 2.077000000000e-03 3.309171599031e-02
+ 2.078000000000e-03 2.235205545881e-01
+ 2.079000000000e-03 5.678945811793e-01
+ 2.080000000000e-03 8.744645531225e-01
+ 2.081000000000e-03 9.725307213149e-01
+ 2.082000000000e-03 8.074893351024e-01
+ 2.083000000000e-03 4.712362936156e-01
+ 2.084000000000e-03 1.509990329045e-01
+ 2.085000000000e-03 2.508731928567e-02
+ 2.086000000000e-03 1.636094474091e-01
+ 2.087000000000e-03 4.894355784782e-01
+ 2.088000000000e-03 8.211440341982e-01
+ 2.089000000000e-03 9.740378274250e-01
+ 2.090000000000e-03 8.629849017548e-01
+ 2.091000000000e-03 5.498201017056e-01
+ 2.092000000000e-03 2.089152108460e-01
+ 2.093000000000e-03 3.008783906432e-02
+ 2.094000000000e-03 1.129099936981e-01
+ 2.095000000000e-03 4.112658698416e-01
+ 2.096000000000e-03 7.590293695004e-01
+ 2.097000000000e-03 9.625639738642e-01
+ 2.098000000000e-03 9.085405604540e-01
+ 2.099000000000e-03 6.270396458201e-01
+ 2.100000000000e-03 2.748023980411e-01
+ 2.101000000000e-03 4.795634206519e-02
+ 2.102000000000e-03 7.281053743472e-02
+ 2.103000000000e-03 3.355260393671e-01
+ 2.104000000000e-03 6.898214949266e-01
+ 2.105000000000e-03 9.384233584068e-01
+ 2.106000000000e-03 9.429088239026e-01
+ 2.107000000000e-03 7.007803609811e-01
+ 2.108000000000e-03 3.468563525696e-01
+ 2.109000000000e-03 7.820352067738e-02
+ 2.110000000000e-03 4.440915433060e-02
+ 2.111000000000e-03 2.642901318424e-01
+ 2.112000000000e-03 6.154155854539e-01
+ 2.113000000000e-03 9.022770429713e-01
+ 2.114000000000e-03 9.651485582583e-01
+ 2.115000000000e-03 7.690229457868e-01
+ 2.116000000000e-03 4.231039629546e-01
+ 2.117000000000e-03 1.200010920444e-01
+ 2.118000000000e-03 2.848358233674e-02
+ 2.119000000000e-03 1.995088575042e-01
+ 2.120000000000e-03 5.378491580363e-01
+ 2.121000000000e-03 8.551148512297e-01
+ 2.122000000000e-03 9.746507549611e-01
+ 2.123000000000e-03 8.298986585671e-01
+ 2.124000000000e-03 5.014572794625e-01
+ 2.125000000000e-03 1.722044796013e-01
+ 2.126000000000e-03 2.546992421932e-02
+ 2.127000000000e-03 1.429561741699e-01
+ 2.128000000000e-03 4.592462766364e-01
+ 2.129000000000e-03 7.982282634679e-01
+ 2.130000000000e-03 9.711552077045e-01
+ 2.131000000000e-03 8.817404906428e-01
+ 2.132000000000e-03 5.797706901131e-01
+ 2.133000000000e-03 2.333841559359e-01
+ 2.134000000000e-03 3.545070540610e-02
+ 2.135000000000e-03 9.618070952088e-02
+ 2.136000000000e-03 3.817593872707e-01
+ 2.137000000000e-03 7.331750509416e-01
+ 2.138000000000e-03 9.547576378747e-01
+ 2.139000000000e-03 9.231288153673e-01
+ 2.140000000000e-03 6.558996757001e-01
+ 2.141000000000e-03 3.018647886906e-01
+ 2.142000000000e-03 5.815261412626e-02
+ 2.143000000000e-03 6.046335378395e-02
+ 2.144000000000e-03 3.075103758476e-01
+ 2.145000000000e-03 6.617366181702e-01
+ 2.146000000000e-03 9.259070733348e-01
+ 2.147000000000e-03 9.529302629056e-01
+ 2.148000000000e-03 7.277595348887e-01
+ 2.149000000000e-03 3.757711175368e-01
+ 2.150000000000e-03 9.295398572656e-02
+ 2.151000000000e-03 3.678218408179e-02
+ 2.152000000000e-03 2.385324628550e-01
+ 2.153000000000e-03 5.858692213031e-01
+ 2.154000000000e-03 8.853935523331e-01
+ 2.155000000000e-03 9.703287562147e-01
+ 2.156000000000e-03 7.933824712706e-01
+ 2.157000000000e-03 4.530793059389e-01
+ 2.158000000000e-03 1.389018262158e-01
+ 2.159000000000e-03 2.578568095992e-02
+ 2.160000000000e-03 1.767145260471e-01
+ 2.161000000000e-03 5.076503983802e-01
+ 2.162000000000e-03 8.343264892491e-01
+ 2.163000000000e-03 9.748478583374e-01
+ 2.164000000000e-03 8.509714791189e-01
+ 2.165000000000e-03 5.316723615018e-01
+ 2.166000000000e-03 1.947379088661e-01
+ 2.167000000000e-03 2.777497052105e-02
+ 2.168000000000e-03 1.237493757823e-01
+ 2.169000000000e-03 4.292220784363e-01
+ 2.170000000000e-03 7.741042946064e-01
+ 2.171000000000e-03 9.663638190602e-01
+ 2.172000000000e-03 8.989495522432e-01
+ 2.173000000000e-03 6.093981072772e-01
+ 2.174000000000e-03 2.589332292500e-01
+ 2.175000000000e-03 4.269557844680e-02
+ 2.176000000000e-03 8.108739943451e-02
+ 2.177000000000e-03 3.527319273307e-01
+ 2.178000000000e-03 7.063760812704e-01
+ 2.179000000000e-03 9.451089636646e-01
+ 2.180000000000e-03 9.360028684202e-01
+ 2.181000000000e-03 6.841281165597e-01
+ 2.182000000000e-03 3.297298751991e-01
+ 2.183000000000e-03 7.013892171152e-02
+ 2.184000000000e-03 4.989684426653e-02
+ 2.185000000000e-03 2.802745364850e-01
+ 2.186000000000e-03 6.329965054631e-01
+ 2.187000000000e-03 9.116653309768e-01
+ 2.188000000000e-03 9.611167668463e-01
+ 2.189000000000e-03 7.538159973092e-01
+ 2.190000000000e-03 4.051891651300e-01
+ 2.191000000000e-03 1.093534971409e-01
+ 2.192000000000e-03 3.103182637500e-02
+ 2.193000000000e-03 2.138340649982e-01
+ 2.194000000000e-03 5.559749792163e-01
+ 2.195000000000e-03 8.669487349300e-01
+ 2.196000000000e-03 9.736035334113e-01
+ 2.197000000000e-03 8.165534301529e-01
+ 2.198000000000e-03 4.832447365234e-01
+ 2.199000000000e-03 1.592654604279e-01
+ 2.200000000000e-03 2.500894174077e-02
+ 2.201000000000e-03 1.552299058191e-01
+ 2.202000000000e-03 4.774206450253e-01
+ 2.203000000000e-03 8.121836860936e-01
+ 2.204000000000e-03 9.731212329281e-01
+ 2.205000000000e-03 8.706224254314e-01
+ 2.206000000000e-03 5.617591307931e-01
+ 2.207000000000e-03 2.185080320775e-01
+ 2.208000000000e-03 3.199311986527e-02
+ 2.209000000000e-03 1.060668638451e-01
+ 2.210000000000e-03 3.994846194995e-01
+ 2.211000000000e-03 7.488698599133e-01
+ 2.212000000000e-03 9.596830726194e-01
+ 2.213000000000e-03 9.145423682941e-01
+ 2.214000000000e-03 6.385823250368e-01
+ 2.215000000000e-03 2.854589250294e-01
+ 2.216000000000e-03 5.179310737310e-02
+ 2.217000000000e-03 6.769121025575e-02
+ 2.218000000000e-03 3.243010876041e-01
+ 2.219000000000e-03 6.787410298919e-01
+ 2.220000000000e-03 9.336570404534e-01
+ 2.221000000000e-03 9.471105635674e-01
+ 2.222000000000e-03 7.116106078442e-01
+ 2.223000000000e-03 3.582847690525e-01
+ 2.224000000000e-03 8.386670525722e-02
+ 2.225000000000e-03 4.115381648540e-02
+ 2.226000000000e-03 2.539288605544e-01
+ 2.227000000000e-03 6.037175902710e-01
+ 2.228000000000e-03 8.957558282333e-01
+ 2.229000000000e-03 9.674351701261e-01
+ 2.230000000000e-03 7.788441869226e-01
+ 2.231000000000e-03 4.349913153976e-01
+ 2.232000000000e-03 1.273356163511e-01
+ 2.233000000000e-03 2.718137736378e-02
+ 2.234000000000e-03 1.902949977289e-01
+ 2.235000000000e-03 5.258539683301e-01
+ 2.236000000000e-03 8.470173153831e-01
+ 2.237000000000e-03 9.749596228972e-01
+ 2.238000000000e-03 8.384419510183e-01
+ 2.239000000000e-03 5.134780469184e-01
+ 2.240000000000e-03 1.810094964478e-01
+ 2.241000000000e-03 2.615651144633e-02
+ 2.242000000000e-03 1.351420364513e-01
+ 2.243000000000e-03 4.472823663486e-01
+ 2.244000000000e-03 7.887761478596e-01
+ 2.245000000000e-03 9.694778737294e-01
+ 2.246000000000e-03 8.887718865507e-01
+ 2.247000000000e-03 5.915956982239e-01
+ 2.248000000000e-03 2.434185504533e-01
+ 2.249000000000e-03 3.810728346200e-02
+ 2.250000000000e-03 8.998027468665e-02
+ 2.251000000000e-03 3.701543737943e-01
+ 2.252000000000e-03 7.226271904670e-01
+ 2.253000000000e-03 9.511400337758e-01
+ 2.254000000000e-03 9.284557683537e-01
+ 2.255000000000e-03 6.672051107434e-01
+ 2.256000000000e-03 3.128537809711e-01
+ 2.257000000000e-03 6.270643579420e-02
+ 2.258000000000e-03 5.604641333563e-02
+ 2.259000000000e-03 2.965820486142e-01
+ 2.260000000000e-03 6.503818533891e-01
+ 2.261000000000e-03 9.204482628791e-01
+ 2.262000000000e-03 9.564069007262e-01
+ 2.263000000000e-03 7.382358110301e-01
+ 2.264000000000e-03 3.874137871528e-01
+ 2.265000000000e-03 9.928035003967e-02
+ 2.266000000000e-03 3.426969065757e-02
+ 2.267000000000e-03 2.285800810525e-01
+ 2.268000000000e-03 5.740184888857e-01
+ 2.269000000000e-03 8.782430185243e-01
+ 2.270000000000e-03 9.718598752954e-01
+ 2.271000000000e-03 8.027427082018e-01
+ 2.272000000000e-03 4.650568322903e-01
+ 2.273000000000e-03 1.468274932441e-01
+ 2.274000000000e-03 2.524643619107e-02
+ 2.275000000000e-03 1.680106237629e-01
+ 2.276000000000e-03 4.956282164783e-01
+ 2.277000000000e-03 8.256800409145e-01
+ 2.278000000000e-03 9.743915308111e-01
+ 2.279000000000e-03 8.589593579322e-01
+ 2.280000000000e-03 5.436567543363e-01
+ 2.281000000000e-03 2.040458436852e-01
+ 2.282000000000e-03 2.922374098146e-02
+ 2.283000000000e-03 1.165322989837e-01
+ 2.284000000000e-03 4.173576601409e-01
+ 2.285000000000e-03 7.641987044055e-01
+ 2.286000000000e-03 9.639325409111e-01
+ 2.287000000000e-03 9.053463344187e-01
+ 2.288000000000e-03 6.210611883122e-01
+ 2.289000000000e-03 2.693685451831e-01
+ 2.290000000000e-03 4.609269128792e-02
+ 2.291000000000e-03 7.555477914897e-02
+ 2.292000000000e-03 3.413501655649e-01
+ 2.293000000000e-03 6.954826019590e-01
+ 2.294000000000e-03 9.407693125407e-01
+ 2.295000000000e-03 9.406333857191e-01
+ 2.296000000000e-03 6.951505062526e-01
+ 2.297000000000e-03 3.410068135843e-01
+ 2.298000000000e-03 7.539135105613e-02
+ 2.299000000000e-03 4.620018469191e-02
+ 2.300000000000e-03 2.696871071996e-01
+ 2.301000000000e-03 6.214134419596e-01
+ 2.302000000000e-03 9.055361430405e-01
+ 2.303000000000e-03 9.638542180832e-01
+ 2.304000000000e-03 7.638958606844e-01
+ 2.305000000000e-03 4.169989204799e-01
+ 2.306000000000e-03 1.163174114851e-01
+ 2.307000000000e-03 2.927235611815e-02
+ 2.308000000000e-03 2.043308922972e-01
+ 2.309000000000e-03 5.440195198791e-01
+ 2.310000000000e-03 8.591978506718e-01
+ 2.311000000000e-03 9.743729567541e-01
+ 2.312000000000e-03 8.254147421922e-01
+ 2.313000000000e-03 4.952639127941e-01
+ 2.314000000000e-03 1.677501612959e-01
+ 2.315000000000e-03 2.523484179297e-02
+ 2.316000000000e-03 1.470712227357e-01
+ 2.317000000000e-03 4.654201758277e-01
+ 2.318000000000e-03 8.030233542203e-01
+ 2.319000000000e-03 9.719015586376e-01
+ 2.320000000000e-03 8.780225296893e-01
+ 2.321000000000e-03 5.736585971994e-01
+ 2.322000000000e-03 2.282811760708e-01
+ 2.323000000000e-03 3.419820422346e-02
+ 2.324000000000e-03 9.947608617012e-02
+ 2.325000000000e-03 3.877677589559e-01
+ 2.326000000000e-03 7.385509251716e-01
+ 2.327000000000e-03 9.565077000191e-01
+ 2.328000000000e-03 9.202786217548e-01
+ 2.329000000000e-03 6.500362289046e-01
+ 2.330000000000e-03 2.962528862738e-01
+ 2.331000000000e-03 5.591699243610e-02
+ 2.332000000000e-03 6.284881856313e-02
+ 2.333000000000e-03 3.131886879449e-01
+ 2.334000000000e-03 6.675460639836e-01
+ 2.335000000000e-03 9.286129233291e-01
+ 2.336000000000e-03 9.510258857817e-01
+ 2.337000000000e-03 7.223052976980e-01
+ 2.338000000000e-03 3.698039678125e-01
+ 2.339000000000e-03 8.979646335845e-02
+ 2.340000000000e-03 3.819241388748e-02
+ 2.341000000000e-03 2.437252215704e-01
+ 2.342000000000e-03 5.919531539654e-01
+ 2.343000000000e-03 8.889810937073e-01
+ 2.344000000000e-03 9.694223446721e-01
+ 2.345000000000e-03 7.884868014554e-01
+ 2.346000000000e-03 4.469203121748e-01
+ 2.347000000000e-03 1.349088681481e-01
+ 2.348000000000e-03 2.618205833334e-02
+ 2.349000000000e-03 1.812795338859e-01
+ 2.350000000000e-03 5.138422166630e-01
+ 2.351000000000e-03 8.386974814680e-01
+ 2.352000000000e-03 9.749642333736e-01
+ 2.353000000000e-03 8.467684387490e-01
+ 2.354000000000e-03 5.254901803852e-01
+ 2.355000000000e-03 1.900188574861e-01
+ 2.356000000000e-03 2.714664114134e-02
+ 2.357000000000e-03 1.275616254577e-01
+ 2.358000000000e-03 4.353522267914e-01
+ 2.359000000000e-03 7.791390432692e-01
+ 2.360000000000e-03 9.674997938837e-01
+ 2.361000000000e-03 8.955542365589e-01
+ 2.362000000000e-03 6.033620304534e-01
+ 2.363000000000e-03 2.536173101426e-01
+ 2.364000000000e-03 4.105974836348e-02
+ 2.365000000000e-03 8.404249704278e-02
+ 2.366000000000e-03 3.586325389682e-01
+ 2.367000000000e-03 7.119367157989e-01
+ 2.368000000000e-03 9.472334309619e-01
+ 2.369000000000e-03 9.335082540857e-01
+ 2.370000000000e-03 6.784034347825e-01
+ 2.371000000000e-03 3.239626584596e-01
+ 2.372000000000e-03 6.754038617744e-02
+ 2.373000000000e-03 5.191386798955e-02
+ 2.374000000000e-03 2.857840302034e-01
+ 2.375000000000e-03 6.389307545228e-01
+ 2.376000000000e-03 9.147201147486e-01
+ 2.377000000000e-03 9.595911658954e-01
+ 2.378000000000e-03 7.485594741511e-01
+ 2.379000000000e-03 3.991285790997e-01
+ 2.380000000000e-03 1.058634139477e-01
+ 2.381000000000e-03 3.205554242736e-02
+ 2.382000000000e-03 2.188015698930e-01
+ 2.383000000000e-03 5.621203404852e-01
+ 2.384000000000e-03 8.708501835717e-01
+ 2.385000000000e-03 9.730887226036e-01
+ 2.386000000000e-03 8.119090092215e-01
+ 2.387000000000e-03 4.770567431116e-01
+ 2.388000000000e-03 1.549794013350e-01
+ 2.389000000000e-03 2.501131688122e-02
+ 2.390000000000e-03 1.595193927024e-01
+ 2.391000000000e-03 4.836088351256e-01
+ 2.392000000000e-03 8.168249630942e-01
+ 2.393000000000e-03 9.736313097428e-01
+ 2.394000000000e-03 8.667172886465e-01
+ 2.395000000000e-03 5.556131808078e-01
+ 2.396000000000e-03 2.135433656935e-01
+ 2.397000000000e-03 3.097408905344e-02
+ 2.398000000000e-03 1.095608702423e-01
+ 2.399000000000e-03 4.055461822370e-01
+ 2.400000000000e-03 7.541238694462e-01
+ 2.401000000000e-03 9.612040692121e-01
+ 2.402000000000e-03 9.114834531617e-01
+ 2.403000000000e-03 6.326467179771e-01
+ 2.404000000000e-03 2.799516028130e-01
+ 2.405000000000e-03 4.978057555051e-02
+ 2.406000000000e-03 7.029405697527e-02
+ 2.407000000000e-03 3.300700343237e-01
+ 2.408000000000e-03 6.844638971819e-01
+ 2.409000000000e-03 9.361473061494e-01
+ 2.410000000000e-03 9.449816348246e-01
+ 2.411000000000e-03 7.060478832193e-01
+ 2.412000000000e-03 3.523856024439e-01
+ 2.413000000000e-03 8.091578320396e-02
+ 2.414000000000e-03 4.279422767889e-02
+ 2.415000000000e-03 2.592472155411e-01
+ 2.416000000000e-03 6.097526014332e-01
+ 2.417000000000e-03 8.991471700809e-01
+ 2.418000000000e-03 9.662945259436e-01
+ 2.419000000000e-03 7.738066733018e-01
+ 2.420000000000e-03 4.288618460284e-01
+ 2.421000000000e-03 1.235271115428e-01
+ 2.422000000000e-03 2.781443233016e-02
+ 2.423000000000e-03 1.950171241841e-01
+ 2.424000000000e-03 5.320358617926e-01
+ 2.425000000000e-03 8.512168655369e-01
+ 2.426000000000e-03 9.748384984534e-01
+ 2.427000000000e-03 8.340675946949e-01
+ 2.428000000000e-03 5.072861229855e-01
+ 2.429000000000e-03 1.764477002392e-01
+ 2.430000000000e-03 2.576487473152e-02
+ 2.431000000000e-03 1.391386245827e-01
+ 2.432000000000e-03 4.534418583433e-01
+ 2.433000000000e-03 7.936689066548e-01
+ 2.434000000000e-03 9.703795858725e-01
+ 2.435000000000e-03 8.851804740475e-01
+ 2.436000000000e-03 5.855108781679e-01
+ 2.437000000000e-03 2.382283821848e-01
+ 2.438000000000e-03 3.670167956961e-02
+ 2.439000000000e-03 9.314188270202e-02
+ 2.440000000000e-03 3.761227939901e-01
+ 2.441000000000e-03 7.280791755484e-01
+ 2.442000000000e-03 9.530398901958e-01
+ 2.443000000000e-03 9.257456462122e-01
+ 2.444000000000e-03 6.613940200933e-01
+ 2.445000000000e-03 3.071773672010e-01
+ 2.446000000000e-03 6.032535550785e-02
+ 2.447000000000e-03 5.828646437595e-02
+ 2.448000000000e-03 3.021959589536e-01
+ 2.449000000000e-03 6.562437686575e-01
+ 2.450000000000e-03 9.232942382774e-01
+ 2.451000000000e-03 9.546522824039e-01
+ 2.452000000000e-03 7.328575795621e-01
+ 2.453000000000e-03 3.814065696917e-01
+ 2.454000000000e-03 9.598899639889e-02
+ 2.455000000000e-03 3.552684360088e-02
+ 2.456000000000e-03 2.336857513062e-01
+ 2.457000000000e-03 5.801298127936e-01
+ 2.458000000000e-03 8.819571792640e-01
+ 2.459000000000e-03 9.711088089193e-01
+ 2.460000000000e-03 7.979446123602e-01
+ 2.461000000000e-03 4.588833116129e-01
+ 2.462000000000e-03 1.427159960368e-01
+ 2.463000000000e-03 2.548626540567e-02
+ 2.464000000000e-03 1.724682412498e-01
+ 2.465000000000e-03 5.018215977204e-01
+ 2.466000000000e-03 8.301606791404e-01
+ 2.467000000000e-03 9.746645834368e-01
+ 2.468000000000e-03 8.548727878407e-01
+ 2.469000000000e-03 5.374859849322e-01
+ 2.470000000000e-03 1.992267913513e-01
+ 2.471000000000e-03 2.843967903079e-02
+ 2.472000000000e-03 1.202197971736e-01
+ 2.473000000000e-03 4.234635003697e-01
+ 2.474000000000e-03 7.693231231919e-01
+ 2.475000000000e-03 9.652222353185e-01
+ 2.476000000000e-03 9.020831959178e-01
+ 2.477000000000e-03 6.150621493306e-01
+ 2.478000000000e-03 2.639739017144e-01
+ 2.479000000000e-03 4.430620877193e-02
+ 2.480000000000e-03 7.837118030860e-02
+ 2.481000000000e-03 3.472012636392e-01
+ 2.482000000000e-03 7.011104752182e-01
+ 2.483000000000e-03 9.430403319891e-01
+ 2.484000000000e-03 9.382830359586e-01
+ 2.485000000000e-03 6.894874742102e-01
+ 2.486000000000e-03 3.351843048483e-01
+ 2.487000000000e-03 7.265136866450e-02
+ 2.488000000000e-03 4.806836503966e-02
+ 2.489000000000e-03 2.751232377876e-01
+ 2.490000000000e-03 6.273906571050e-01
+ 2.491000000000e-03 9.087262983749e-01
+ 2.492000000000e-03 9.624810185842e-01
+ 2.493000000000e-03 7.587239109492e-01
+ 2.494000000000e-03 4.109079889234e-01
+ 2.495000000000e-03 1.126989603630e-01
+ 2.496000000000e-03 3.014115776672e-02
+ 2.497000000000e-03 2.092031934563e-01
+ 2.498000000000e-03 5.501823980137e-01
+ 2.499000000000e-03 8.632197832990e-01
+ 2.500000000000e-03 9.740145109443e-01
+ 2.501000000000e-03 8.208755024299e-01
+ 2.502000000000e-03 4.890713513024e-01
+ 2.503000000000e-03 1.633523284048e-01
+ 2.504000000000e-03 2.508047364699e-02
+ 2.505000000000e-03 1.512462723184e-01
+ 2.506000000000e-03 4.715999538953e-01
+ 2.507000000000e-03 8.077669283194e-01
+ 2.508000000000e-03 9.725676821275e-01
+ 2.509000000000e-03 8.742403015587e-01
+ 2.510000000000e-03 5.675339816718e-01
+ 2.511000000000e-03 2.232243908115e-01
+ 2.512000000000e-03 3.302489347020e-02
+ 2.513000000000e-03 1.028395554307e-01
+ 2.514000000000e-03 3.937952111157e-01
+ 2.515000000000e-03 7.438862436323e-01
+ 2.516000000000e-03 9.581801518126e-01
+ 2.517000000000e-03 9.173569770555e-01
+ 2.518000000000e-03 6.441472746218e-01
+ 2.519000000000e-03 2.906756226702e-01
+ 2.520000000000e-03 5.375686878905e-02
+ 2.521000000000e-03 6.530860291359e-02
+ 2.522000000000e-03 3.188987596194e-01
+ 2.523000000000e-03 6.733270254827e-01
+ 2.524000000000e-03 9.312459053316e-01
+ 2.525000000000e-03 9.490448302639e-01
+ 2.526000000000e-03 7.168132666386e-01
+ 2.527000000000e-03 3.638589525665e-01
+ 2.528000000000e-03 8.670867922343e-02
+ 2.529000000000e-03 3.968115507155e-02
+ 2.530000000000e-03 2.489615492673e-01
+ 2.531000000000e-03 5.980214537773e-01
+ 2.532000000000e-03 8.925025048516e-01
+ 2.533000000000e-03 9.684361271748e-01
+ 2.534000000000e-03 7.835420863297e-01
+ 2.535000000000e-03 4.407703424276e-01
+ 2.536000000000e-03 1.309779788052e-01
+ 2.537000000000e-03 2.665898895194e-02
+ 2.538000000000e-03 1.858987270259e-01
+ 2.539000000000e-03 5.200316816461e-01
+ 2.540000000000e-03 8.430108921163e-01
+ 2.541000000000e-03 9.749998602849e-01
+ 2.542000000000e-03 8.425064446745e-01
+ 2.543000000000e-03 5.193036657123e-01
+ 2.544000000000e-03 1.853525056448e-01
+ 2.545000000000e-03 2.659870101917e-02
+ 2.546000000000e-03 1.314371929544e-01
+ 2.547000000000e-03 4.414933658404e-01
+ 2.548000000000e-03 7.841263358231e-01
+ 2.549000000000e-03 9.685562896033e-01
+ 2.550000000000e-03 8.920916731522e-01
+ 2.551000000000e-03 5.973083811693e-01
+ 2.552000000000e-03 2.483432782741e-01
+ 2.553000000000e-03 3.950194218628e-02
+ 2.554000000000e-03 8.706831110935e-02
+ 2.555000000000e-03 3.645571843257e-01
+ 2.556000000000e-03 7.174613192092e-01
+ 2.557000000000e-03 9.492818646163e-01
+ 2.558000000000e-03 9.309399395098e-01
+ 2.559000000000e-03 6.726484228418e-01
+ 2.560000000000e-03 3.182253696268e-01
+ 2.561000000000e-03 6.501537260661e-02
+ 2.562000000000e-03 5.400707032223e-02
+ 2.563000000000e-03 2.913299425332e-01
+ 2.564000000000e-03 6.448413841242e-01
+ 2.565000000000e-03 9.177043924292e-01
+ 2.566000000000e-03 9.579874303771e-01
+ 2.567000000000e-03 7.432606936816e-01
+ 2.568000000000e-03 3.930851421042e-01
+ 2.569000000000e-03 1.024403374638e-01
+ 2.570000000000e-03 3.315881318058e-02
+ 2.571000000000e-03 2.238168810105e-01
+ 2.572000000000e-03 5.682551407464e-01
+ 2.573000000000e-03 8.746885843987e-01
+ 2.574000000000e-03 9.724934825246e-01
+ 2.575000000000e-03 8.072115609971e-01
+ 2.576000000000e-03 4.708726502566e-01
+ 2.577000000000e-03 1.507519987987e-01
+ 2.578000000000e-03 2.509444430325e-02
+ 2.579000000000e-03 1.638667643034e-01
+ 2.580000000000e-03 4.897998118690e-01
+ 2.581000000000e-03 8.214123770459e-01
+ 2.582000000000e-03 9.740608650415e-01
+ 2.583000000000e-03 8.627498066757e-01
+ 2.584000000000e-03 5.494577760894e-01
+ 2.585000000000e-03 2.086273994735e-01
+ 2.586000000000e-03 3.003479679912e-02
+ 2.587000000000e-03 1.131212547485e-01
+ 2.588000000000e-03 4.116238029598e-01
+ 2.589000000000e-03 7.593346756713e-01
+ 2.590000000000e-03 9.626466570297e-01
+ 2.591000000000e-03 9.083545821991e-01
+ 2.592000000000e-03 6.266885598007e-01
+ 2.593000000000e-03 2.744816907724e-01
+ 2.594000000000e-03 4.784458501626e-02
+ 2.595000000000e-03 7.296995750967e-02
+ 2.596000000000e-03 3.358678706419e-01
+ 2.597000000000e-03 6.901554039761e-01
+ 2.598000000000e-03 9.385634229417e-01
+ 2.599000000000e-03 9.427770552641e-01
+ 2.600000000000e-03 7.004501286300e-01
+ 2.601000000000e-03 3.465115315902e-01
+ 2.602000000000e-03 7.803610917802e-02
+ 2.603000000000e-03 4.451236790167e-02
+ 2.604000000000e-03 2.646065006327e-01
+ 2.605000000000e-03 6.157689536814e-01
+ 2.606000000000e-03 9.024706533757e-01
+ 2.607000000000e-03 9.650746075632e-01
+ 2.608000000000e-03 7.687226101222e-01
+ 2.609000000000e-03 4.227444707752e-01
+ 2.610000000000e-03 1.197826104586e-01
+ 2.611000000000e-03 2.852776302369e-02
+ 2.612000000000e-03 1.997911004284e-01
+ 2.613000000000e-03 5.382123088751e-01
+ 2.614000000000e-03 8.553567057139e-01
+ 2.615000000000e-03 9.746366472607e-01
+ 2.616000000000e-03 8.296364439227e-01
+ 2.617000000000e-03 5.010929603471e-01
+ 2.618000000000e-03 1.719409107863e-01
+ 2.619000000000e-03 2.545386218678e-02
+ 2.620000000000e-03 1.431965623429e-01
+ 2.621000000000e-03 4.596092656343e-01
+ 2.622000000000e-03 7.985117391357e-01
+ 2.623000000000e-03 9.712013293213e-01
+ 2.624000000000e-03 8.815235774534e-01
+ 2.625000000000e-03 5.794115205055e-01
+ 2.626000000000e-03 2.330827174089e-01
+ 2.627000000000e-03 3.537484049364e-02
+ 2.628000000000e-03 9.637266019951e-02
+ 2.629000000000e-03 3.821122744077e-01
+ 2.630000000000e-03 7.334923851505e-01
+ 2.631000000000e-03 9.548627258234e-01
+ 2.632000000000e-03 9.229631435414e-01
+ 2.633000000000e-03 6.555554910308e-01
+ 2.634000000000e-03 3.015337349854e-01
+ 2.635000000000e-03 5.801902380388e-02
+ 2.636000000000e-03 6.060161062817e-02
+ 2.637000000000e-03 3.078434977311e-01
+ 2.638000000000e-03 6.620791211020e-01
+ 2.639000000000e-03 9.260682499074e-01
+ 2.640000000000e-03 9.528203691683e-01
+ 2.641000000000e-03 7.274397602439e-01
+ 2.642000000000e-03 3.754195141638e-01
+ 2.643000000000e-03 9.276632820573e-02
+ 2.644000000000e-03 3.686296109317e-02
+ 2.645000000000e-03 2.388366973400e-01
+ 2.646000000000e-03 5.862275139239e-01
+ 2.647000000000e-03 8.856064039017e-01
+ 2.648000000000e-03 9.702776498746e-01
+ 2.649000000000e-03 7.930958632968e-01
+ 2.650000000000e-03 4.527167811366e-01
+ 2.651000000000e-03 1.386652402735e-01
+ 2.652000000000e-03 2.580676615639e-02
+ 2.653000000000e-03 1.769815420357e-01
+ 2.654000000000e-03 5.080146692748e-01
+ 2.655000000000e-03 8.345851871276e-01
+ 2.656000000000e-03 9.748569388807e-01
+ 2.657000000000e-03 8.507258862332e-01
+ 2.658000000000e-03 5.313088425788e-01
+ 2.659000000000e-03 1.944588731258e-01
+ 2.660000000000e-03 2.773578650975e-02
+ 2.661000000000e-03 1.239718613606e-01
+ 2.662000000000e-03 4.295823524811e-01
+ 2.663000000000e-03 7.744017546627e-01
+ 2.664000000000e-03 9.664328378270e-01
+ 2.665000000000e-03 8.987516997135e-01
+ 2.666000000000e-03 6.090435487648e-01
+ 2.667000000000e-03 2.586193847721e-01
+ 2.668000000000e-03 4.259719823503e-02
+ 2.669000000000e-03 8.125926210060e-02
+ 2.670000000000e-03 3.530783388516e-01
+ 2.671000000000e-03 7.067041579161e-01
+ 2.672000000000e-03 9.452360306584e-01
+ 2.673000000000e-03 9.358581742017e-01
+ 2.674000000000e-03 6.837922276195e-01
+ 2.675000000000e-03 3.293898162397e-01
+ 2.676000000000e-03 6.998403932394e-02
+ 2.677000000000e-03 5.001337776666e-02
+ 2.678000000000e-03 2.805975994162e-01
+ 2.679000000000e-03 6.333462147109e-01
+ 2.680000000000e-03 9.118469666199e-01
+ 2.681000000000e-03 9.610291932173e-01
+ 2.682000000000e-03 7.535079758586e-01
+ 2.683000000000e-03 4.048322037976e-01
+ 2.684000000000e-03 1.091463538466e-01
+ 2.685000000000e-03 3.108983957848e-02
+ 2.686000000000e-03 2.141249326472e-01
+ 2.687000000000e-03 5.563367446963e-01
+ 2.688000000000e-03 8.671799653471e-01
+ 2.689000000000e-03 9.735754784709e-01
+ 2.690000000000e-03 8.162817109913e-01
+ 2.691000000000e-03 4.828806477777e-01
+ 2.692000000000e-03 1.590117285986e-01
+ 2.693000000000e-03 2.500684602531e-02
+ 2.694000000000e-03 1.554806131227e-01
+ 2.695000000000e-03 4.777845602221e-01
+ 2.696000000000e-03 8.124581793160e-01
+ 2.697000000000e-03 9.731534649275e-01
+ 2.698000000000e-03 8.703944492635e-01
+ 2.699000000000e-03 5.613978847696e-01
+ 2.700000000000e-03 2.182146598562e-01
+ 2.701000000000e-03 3.193097261954e-02
+ 2.702000000000e-03 1.062705454832e-01
+ 2.703000000000e-03 3.998407190299e-01
+ 2.704000000000e-03 7.491800992721e-01
+ 2.705000000000e-03 9.597747089238e-01
+ 2.706000000000e-03 9.143643779749e-01
+ 2.707000000000e-03 6.382338140262e-01
+ 2.708000000000e-03 2.851339460640e-01
+ 2.709000000000e-03 5.167261042516e-02
+ 2.710000000000e-03 6.784228865025e-02
+ 2.711000000000e-03 3.246396201081e-01
+ 2.712000000000e-03 6.790785198527e-01
+ 2.713000000000e-03 9.338055717120e-01
+ 2.714000000000e-03 9.469874331492e-01
+ 2.715000000000e-03 7.112843754043e-01
+ 2.716000000000e-03 3.579370825038e-01
+ 2.717000000000e-03 8.369115827212e-02
+ 2.718000000000e-03 4.124815453476e-02
+ 2.719000000000e-03 2.542405557235e-01
+ 2.720000000000e-03 6.040730890743e-01
+ 2.721000000000e-03 8.959571870950e-01
+ 2.722000000000e-03 9.673702713884e-01
+ 2.723000000000e-03 7.785491665390e-01
+ 2.724000000000e-03 4.346304422465e-01
+ 2.725000000000e-03 1.271098264733e-01
+ 2.726000000000e-03 2.721639173324e-02
+ 2.727000000000e-03 1.905713201633e-01
+ 2.728000000000e-03 5.262177410660e-01
+ 2.729000000000e-03 8.472659878760e-01
+ 2.730000000000e-03 9.749547330144e-01
+ 2.731000000000e-03 8.381862214718e-01
+ 2.732000000000e-03 5.131138692452e-01
+ 2.733000000000e-03 1.807396466633e-01
+ 2.734000000000e-03 2.613124330921e-02
+ 2.735000000000e-03 1.353754193912e-01
+ 2.736000000000e-03 4.476444515352e-01
+ 2.737000000000e-03 7.890653243844e-01
+ 2.738000000000e-03 9.695331266050e-01
+ 2.739000000000e-03 8.885624506896e-01
+ 2.740000000000e-03 5.912381885989e-01
+ 2.741000000000e-03 2.431120302763e-01
+ 2.742000000000e-03 3.802242475601e-02
+ 2.743000000000e-03 9.016432721897e-02
+ 2.744000000000e-03 3.705048561612e-01
+ 2.745000000000e-03 7.229489522701e-01
+ 2.746000000000e-03 9.512539163758e-01
+ 2.747000000000e-03 9.282983613288e-01
+ 2.748000000000e-03 6.668640591408e-01
+ 2.749000000000e-03 3.125189840904e-01
+ 2.750000000000e-03 6.256431027369e-02
+ 2.751000000000e-03 5.617609540167e-02
+ 2.752000000000e-03 2.969113306205e-01
+ 2.753000000000e-03 6.507273894079e-01
+ 2.754000000000e-03 9.206176566646e-01
+ 2.755000000000e-03 9.563058329408e-01
+ 2.756000000000e-03 7.379205567405e-01
+ 2.757000000000e-03 3.870598815812e-01
+ 2.758000000000e-03 9.908484964223e-02
+ 2.759000000000e-03 3.434145106886e-02
+ 2.760000000000e-03 2.288791457036e-01
+ 2.761000000000e-03 5.743783370291e-01
+ 2.762000000000e-03 8.784632848488e-01
+ 2.763000000000e-03 9.718179143701e-01
+ 2.764000000000e-03 8.024618840873e-01
+ 2.765000000000e-03 4.646935093089e-01
+ 2.766000000000e-03 1.465839715146e-01
+ 2.767000000000e-03 2.525830987446e-02
+ 2.768000000000e-03 1.682712815306e-01
+ 2.769000000000e-03 4.959925227347e-01
+ 2.770000000000e-03 8.259451480479e-01
+ 2.771000000000e-03 9.744098257958e-01
+ 2.772000000000e-03 8.587206540260e-01
+ 2.773000000000e-03 5.432939631111e-01
+ 2.774000000000e-03 2.037609691753e-01
+ 2.775000000000e-03 2.917540279031e-02
+ 2.776000000000e-03 1.167474120665e-01
+ 2.777000000000e-03 4.177164484185e-01
+ 2.778000000000e-03 7.645013927057e-01
+ 2.779000000000e-03 9.640105908195e-01
+ 2.780000000000e-03 9.051562873420e-01
+ 2.781000000000e-03 6.207088634476e-01
+ 2.782000000000e-03 2.690501188410e-01
+ 2.783000000000e-03 4.598546490583e-02
+ 2.784000000000e-03 7.571845693207e-02
+ 2.785000000000e-03 3.416936108754e-01
+ 2.786000000000e-03 6.958145826681e-01
+ 2.787000000000e-03 9.409049800692e-01
+ 2.788000000000e-03 9.404971996840e-01
+ 2.789000000000e-03 6.948182957441e-01
+ 2.790000000000e-03 3.406635551350e-01
+ 2.791000000000e-03 7.522817274940e-02
+ 2.792000000000e-03 4.630794505469e-02
+ 2.793000000000e-03 2.700058047034e-01
+ 2.794000000000e-03 6.217656241827e-01
+ 2.795000000000e-03 9.057257130959e-01
+ 2.796000000000e-03 9.637756223818e-01
+ 2.797000000000e-03 7.635928617199e-01
+ 2.798000000000e-03 4.166402296461e-01
+ 2.799000000000e-03 1.161027496970e-01
+ 2.800000000000e-03 2.932124817179e-02
+ 2.801000000000e-03 2.046161148438e-01
+ 2.802000000000e-03 5.443822595266e-01
+ 2.803000000000e-03 8.594361321046e-01
+ 2.804000000000e-03 9.743541036356e-01
+ 2.805000000000e-03 8.251492520365e-01
+ 2.806000000000e-03 4.948996118957e-01
+ 2.807000000000e-03 1.674898942828e-01
+ 2.808000000000e-03 2.522352668699e-02
+ 2.809000000000e-03 1.473151598464e-01
+ 2.810000000000e-03 4.657835397077e-01
+ 2.811000000000e-03 8.033038219781e-01
+ 2.812000000000e-03 9.719429643723e-01
+ 2.813000000000e-03 8.778018184731e-01
+ 2.814000000000e-03 5.732986621815e-01
+ 2.815000000000e-03 2.279824309342e-01
+ 2.816000000000e-03 3.412699180848e-02
+ 2.817000000000e-03 9.967205791844e-02
+ 2.818000000000e-03 3.881217967825e-01
+ 2.819000000000e-03 7.388658989799e-01
+ 2.820000000000e-03 9.566082307603e-01
+ 2.821000000000e-03 9.201087333912e-01
+ 2.822000000000e-03 6.496905161576e-01
+ 2.823000000000e-03 2.959238437924e-01
+ 2.824000000000e-03 5.578783277907e-02
+ 2.825000000000e-03 6.299145849691e-02
+ 2.826000000000e-03 3.135237048152e-01
+ 2.827000000000e-03 6.678869186610e-01
+ 2.828000000000e-03 9.287698261626e-01
+ 2.829000000000e-03 9.509114724607e-01
+ 2.830000000000e-03 7.219832741525e-01
+ 2.831000000000e-03 3.694536384216e-01
+ 2.832000000000e-03 8.961289334228e-02
+ 2.833000000000e-03 3.827781598253e-02
+ 2.834000000000e-03 2.440320434475e-01
+ 2.835000000000e-03 5.923105556134e-01
+ 2.836000000000e-03 8.891900720364e-01
+ 2.837000000000e-03 9.693665394657e-01
+ 2.838000000000e-03 7.881972853415e-01
+ 2.839000000000e-03 4.465582892262e-01
+ 2.840000000000e-03 1.346759146185e-01
+ 2.841000000000e-03 2.620788395526e-02
+ 2.842000000000e-03 1.815497588193e-01
+ 2.843000000000e-03 5.142063782646e-01
+ 2.844000000000e-03 8.389528126707e-01
+ 2.845000000000e-03 9.749685644407e-01
+ 2.846000000000e-03 8.465193581198e-01
+ 2.847000000000e-03 5.251263774449e-01
+ 2.848000000000e-03 1.897428995972e-01
+ 2.849000000000e-03 2.711218308633e-02
+ 2.850000000000e-03 1.277878536602e-01
+ 2.851000000000e-03 4.357131762161e-01
+ 2.852000000000e-03 7.794337354057e-01
+ 2.853000000000e-03 9.675641426234e-01
+ 2.854000000000e-03 8.953524121898e-01
+ 2.855000000000e-03 6.030064098304e-01
+ 2.856000000000e-03 2.533059046715e-01
+ 2.857000000000e-03 4.096595022420e-02
+ 2.858000000000e-03 8.421853352546e-02
+ 2.859000000000e-03 3.589803920470e-01
+ 2.860000000000e-03 7.122626990770e-01
+ 2.861000000000e-03 9.473560352605e-01
+ 2.862000000000e-03 9.333592126962e-01
+ 2.863000000000e-03 6.780657347229e-01
+ 2.864000000000e-03 3.236243328731e-01
+ 2.865000000000e-03 6.738981650391e-02
+ 2.866000000000e-03 5.203489220359e-02
+ 2.867000000000e-03 2.861092613954e-01
+ 2.868000000000e-03 6.392791022797e-01
+ 2.869000000000e-03 9.148976172341e-01
+ 2.870000000000e-03 9.594989888056e-01
+ 2.871000000000e-03 7.482489421674e-01
+ 2.872000000000e-03 3.987725980400e-01
+ 2.873000000000e-03 1.056601959106e-01
+ 2.874000000000e-03 3.211824026916e-02
+ 2.875000000000e-03 2.190952731304e-01
+ 2.876000000000e-03 5.624815136337e-01
+ 2.877000000000e-03 8.710777235504e-01
+ 2.878000000000e-03 9.730559339733e-01
+ 2.879000000000e-03 8.116341488613e-01
+ 2.880000000000e-03 4.766928546947e-01
+ 2.881000000000e-03 1.547290998176e-01
+ 2.882000000000e-03 2.501397144529e-02
+ 2.883000000000e-03 1.597735252729e-01
+ 2.884000000000e-03 4.839729433705e-01
+ 2.885000000000e-03 8.170963096557e-01
+ 2.886000000000e-03 9.736588074493e-01
+ 2.887000000000e-03 8.664856266325e-01
+ 2.888000000000e-03 5.552513496833e-01
+ 2.889000000000e-03 2.132528349036e-01
+ 2.890000000000e-03 3.091662764770e-02
+ 2.891000000000e-03 1.097684730291e-01
+ 2.892000000000e-03 4.059032549088e-01
+ 2.893000000000e-03 7.544315920890e-01
+ 2.894000000000e-03 9.612911002636e-01
+ 2.895000000000e-03 9.113013332814e-01
+ 2.896000000000e-03 6.322968524581e-01
+ 2.897000000000e-03 2.796287985895e-01
+ 2.898000000000e-03 4.966457168692e-02
+ 2.899000000000e-03 7.044944502398e-02
+ 2.900000000000e-03 3.304102934139e-01
+ 2.901000000000e-03 6.847995692889e-01
+ 2.902000000000e-03 9.362914873045e-01
+ 2.903000000000e-03 9.448540442134e-01
+ 2.904000000000e-03 7.057195639553e-01
+ 2.905000000000e-03 3.520393643949e-01
+ 2.906000000000e-03 8.074441350976e-02
+ 2.907000000000e-03 4.289314587344e-02
+ 2.908000000000e-03 2.595613434609e-01
+ 2.909000000000e-03 6.101070310248e-01
+ 2.910000000000e-03 8.993445531109e-01
+ 2.911000000000e-03 9.662249585179e-01
+ 2.912000000000e-03 7.735088909236e-01
+ 2.913000000000e-03 4.285016554691e-01
+ 2.914000000000e-03 1.233050687724e-01
+ 2.915000000000e-03 2.785417191392e-02
+ 2.916000000000e-03 1.952965189157e-01
+ 2.917000000000e-03 5.323993432377e-01
+ 2.918000000000e-03 8.514620453432e-01
+ 2.919000000000e-03 9.748288592341e-01
+ 2.920000000000e-03 8.338085036172e-01
+ 2.921000000000e-03 5.069218433041e-01
+ 2.922000000000e-03 1.761810647687e-01
+ 2.923000000000e-03 2.574434748341e-02
+ 2.924000000000e-03 1.393756352352e-01
+ 2.925000000000e-03 4.538044381369e-01
+ 2.926000000000e-03 7.939551692814e-01
+ 2.927000000000e-03 9.704301388181e-01
+ 2.928000000000e-03 8.849671691701e-01
+ 2.929000000000e-03 5.851524847285e-01
+ 2.930000000000e-03 2.379244555079e-01
+ 2.931000000000e-03 3.662144760386e-02
+ 2.932000000000e-03 9.333001902167e-02
+ 2.933000000000e-03 3.764745433174e-01
+ 2.934000000000e-03 7.283986820351e-01
+ 2.935000000000e-03 9.531492509743e-01
+ 2.936000000000e-03 9.255839686343e-01
+ 2.937000000000e-03 6.610513270722e-01
+ 2.938000000000e-03 3.068444719866e-01
+ 2.939000000000e-03 6.018761588094e-02
+ 2.940000000000e-03 5.842057447445e-02
+ 2.941000000000e-03 3.025272455796e-01
+ 2.942000000000e-03 6.565877697010e-01
+ 2.943000000000e-03 9.234594121745e-01
+ 2.944000000000e-03 9.545466594728e-01
+ 2.945000000000e-03 7.325399711982e-01
+ 2.946000000000e-03 3.810538218780e-01
+ 2.947000000000e-03 9.579752094606e-02
+ 2.948000000000e-03 3.560325503332e-02
+ 2.949000000000e-03 2.339875033423e-01
+ 2.950000000000e-03 5.804888883359e-01
+ 2.951000000000e-03 8.821736431900e-01
+ 2.952000000000e-03 9.710621329929e-01
+ 2.953000000000e-03 7.976607859792e-01
+ 2.954000000000e-03 4.585203707771e-01
+ 2.955000000000e-03 1.424760280846e-01
+ 2.956000000000e-03 2.550288573624e-02
+ 2.957000000000e-03 1.727321955771e-01
+ 2.958000000000e-03 5.021859149069e-01
+ 2.959000000000e-03 8.304225054889e-01
+ 2.960000000000e-03 9.746781326795e-01
+ 2.961000000000e-03 8.546305156890e-01
+ 2.962000000000e-03 5.371227897757e-01
+ 2.963000000000e-03 1.989449021354e-01
+ 2.964000000000e-03 2.839605313158e-02
+ 2.965000000000e-03 1.204387257179e-01
+ 2.966000000000e-03 4.238230828094e-01
+ 2.967000000000e-03 7.696231421613e-01
+ 2.968000000000e-03 9.652956387005e-01
+ 2.969000000000e-03 9.018891123290e-01
+ 2.970000000000e-03 6.147086455189e-01
+ 2.971000000000e-03 2.636578104343e-01
+ 2.972000000000e-03 4.420353128613e-02
+ 2.973000000000e-03 7.853908797334e-02
+ 2.974000000000e-03 3.475462645967e-01
+ 2.975000000000e-03 7.014404711474e-01
+ 2.976000000000e-03 9.431715794465e-01
+ 2.977000000000e-03 9.381424556798e-01
+ 2.978000000000e-03 6.891533420230e-01
+ 2.979000000000e-03 3.348426672861e-01
+ 2.980000000000e-03 7.249245129239e-02
+ 2.981000000000e-03 4.818065387397e-02
+ 2.982000000000e-03 2.754442098234e-01
+ 2.983000000000e-03 6.277415934495e-01
+ 2.984000000000e-03 9.089117958528e-01
+ 2.985000000000e-03 9.623977912385e-01
+ 2.986000000000e-03 7.584183001974e-01
+ 2.987000000000e-03 4.105501604156e-01
+ 2.988000000000e-03 1.124881548669e-01
+ 2.989000000000e-03 3.019475287500e-02
+ 2.990000000000e-03 2.094913471349e-01
+ 2.991000000000e-03 5.505446648010e-01
+ 2.992000000000e-03 8.634544511706e-01
+ 2.993000000000e-03 9.739909156131e-01
+ 2.994000000000e-03 8.206067818985e-01
+ 2.995000000000e-03 4.887071305554e-01
+ 2.996000000000e-03 1.630954074416e-01
+ 2.997000000000e-03 2.507390739122e-02
+ 2.998000000000e-03 1.514937168954e-01
+ 2.999000000000e-03 4.719636308821e-01
+ 3.000000000000e-03 8.080443404854e-01
+ 3.001000000000e-03 9.726043649408e-01
+ 3.002000000000e-03 8.740158298389e-01
+ 3.003000000000e-03 5.671733424356e-01
+ 3.004000000000e-03 2.229283898548e-01
+ 3.005000000000e-03 3.295834565948e-02
+ 3.006000000000e-03 1.030395149319e-01
+ 3.007000000000e-03 3.941503394422e-01
+ 3.008000000000e-03 7.441988034915e-01
+ 3.009000000000e-03 9.582761082554e-01
+ 3.010000000000e-03 9.171829010370e-01
+ 3.011000000000e-03 6.438000925712e-01
+ 3.012000000000e-03 2.903486473525e-01
+ 3.013000000000e-03 5.363216175559e-02
+ 3.014000000000e-03 6.545560168692e-02
+ 3.015000000000e-03 3.192356145206e-01
+ 3.016000000000e-03 6.736661739571e-01
+ 3.017000000000e-03 9.313985077512e-01
+ 3.018000000000e-03 9.489259168106e-01
+ 3.019000000000e-03 7.164890489394e-01
+ 3.020000000000e-03 3.635099567165e-01
+ 3.021000000000e-03 8.652922792055e-02
+ 3.022000000000e-03 3.977116773114e-02
+ 3.023000000000e-03 2.492709063743e-01
+ 3.024000000000e-03 5.983779036911e-01
+ 3.025000000000e-03 8.927075744132e-01
+ 3.026000000000e-03 9.683756325895e-01
+ 3.027000000000e-03 7.832497112962e-01
+ 3.028000000000e-03 4.404088828796e-01
+ 3.029000000000e-03 1.307486972924e-01
+ 3.030000000000e-03 2.668955060872e-02
+ 3.031000000000e-03 1.861721149635e-01
+ 3.032000000000e-03 5.203956720440e-01
+ 3.033000000000e-03 8.432628132347e-01
+ 3.034000000000e-03 9.749994411396e-01
+ 3.035000000000e-03 8.422539186477e-01
+ 3.036000000000e-03 5.189396406044e-01
+ 3.037000000000e-03 1.850796725224e-01
+ 3.038000000000e-03 2.656897477864e-02
+ 3.039000000000e-03 1.316671253205e-01
+ 3.040000000000e-03 4.418549292801e-01
+ 3.041000000000e-03 7.844182099395e-01
+ 3.042000000000e-03 9.686159573758e-01
+ 3.043000000000e-03 8.918859112558e-01
+ 3.044000000000e-03 5.969517588942e-01
+ 3.045000000000e-03 2.480343647512e-01
+ 3.046000000000e-03 3.941274206604e-02
+ 3.047000000000e-03 8.724849148092e-02
+ 3.048000000000e-03 3.649064198245e-01
+ 3.049000000000e-03 7.177851536998e-01
+ 3.050000000000e-03 9.493999853759e-01
+ 3.051000000000e-03 9.307865762876e-01
+ 3.052000000000e-03 6.723089690747e-01
+ 3.053000000000e-03 3.178888349313e-01
+ 3.054000000000e-03 6.486914124540e-02
+ 3.055000000000e-03 5.413256467491e-02
+ 3.056000000000e-03 2.916572866940e-01
+ 3.057000000000e-03 6.451883111678e-01
+ 3.058000000000e-03 9.178777315800e-01
+ 3.059000000000e-03 9.578906654977e-01
+ 3.060000000000e-03 7.429477039583e-01
+ 3.061000000000e-03 3.927302018367e-01
+ 3.062000000000e-03 1.022410792326e-01
+ 3.063000000000e-03 3.322618500148e-02
+ 3.064000000000e-03 2.241133699044e-01
+ 3.065000000000e-03 5.686156601605e-01
+ 3.066000000000e-03 8.749123952551e-01
+ 3.067000000000e-03 9.724559657785e-01
+ 3.068000000000e-03 8.069336061672e-01
+ 3.069000000000e-03 4.705090240325e-01
+ 3.070000000000e-03 1.505051701464e-01
+ 3.071000000000e-03 2.510184869554e-02
+ 3.072000000000e-03 1.641242789364e-01
+ 3.073000000000e-03 4.901640512603e-01
+ 3.074000000000e-03 8.216805308150e-01
+ 3.075000000000e-03 9.740836237801e-01
+ 3.076000000000e-03 8.625144982003e-01
+ 3.077000000000e-03 5.490954213785e-01
+ 3.078000000000e-03 2.083397595078e-01
+ 3.079000000000e-03 2.998203100235e-02
+ 3.080000000000e-03 1.133327433896e-01
+ 3.081000000000e-03 4.119817880675e-01
+ 3.082000000000e-03 7.596398292824e-01
+ 3.083000000000e-03 9.627290680322e-01
+ 3.084000000000e-03 9.081683637196e-01
+ 3.085000000000e-03 6.263373992538e-01
+ 3.086000000000e-03 2.741611161702e-01
+ 3.087000000000e-03 4.773309395874e-02
+ 3.088000000000e-03 7.312962879529e-02
+ 3.089000000000e-03 3.362097984715e-01
+ 3.090000000000e-03 6.904892011620e-01
+ 3.091000000000e-03 9.387032294811e-01
+ 3.092000000000e-03 9.426450261514e-01
+ 3.093000000000e-03 7.001197783593e-01
+ 3.094000000000e-03 3.461668009041e-01
+ 3.095000000000e-03 7.786894590920e-02
+ 3.096000000000e-03 4.461584942438e-02
+ 3.097000000000e-03 2.649230078989e-01
+ 3.098000000000e-03 6.161222538051e-01
+ 3.099000000000e-03 9.026640270171e-01
+ 3.100000000000e-03 9.650003832766e-01
+ 3.101000000000e-03 7.684221163752e-01
+ 3.102000000000e-03 4.223850240432e-01
+ 3.103000000000e-03 1.195643525448e-01
+ 3.104000000000e-03 2.857222106559e-02
+ 3.105000000000e-03 2.000735199579e-01
+ 3.106000000000e-03 5.385754372344e-01
+ 3.107000000000e-03 8.555983511508e-01
+ 3.108000000000e-03 9.746222603437e-01
+ 3.109000000000e-03 8.293740353617e-01
+ 3.110000000000e-03 5.007286405887e-01
+ 3.111000000000e-03 1.716775349598e-01
+ 3.112000000000e-03 2.543807931750e-02
+ 3.113000000000e-03 1.434371604141e-01
+ 3.114000000000e-03 4.599722783931e-01
+ 3.115000000000e-03 7.987950391967e-01
+ 3.116000000000e-03 9.712471737425e-01
+ 3.117000000000e-03 8.813064398234e-01
+ 3.118000000000e-03 5.790523041820e-01
+ 3.119000000000e-03 2.327814359023e-01
+ 3.120000000000e-03 3.529924890821e-02
+ 3.121000000000e-03 9.656484832170e-02
+ 3.122000000000e-03 3.824652308952e-01
+ 3.123000000000e-03 7.338095820018e-01
+ 3.124000000000e-03 9.549675461880e-01
+ 3.125000000000e-03 9.227972228971e-01
+ 3.126000000000e-03 6.552112148523e-01
+ 3.127000000000e-03 3.012027980328e-01
+ 3.128000000000e-03 5.788569348757e-02
+ 3.129000000000e-03 6.074012595914e-02
+ 3.130000000000e-03 3.081767326553e-01
+ 3.131000000000e-03 6.624215286866e-01
+ 3.132000000000e-03 9.262291758349e-01
+ 3.133000000000e-03 9.527102090483e-01
+ 3.134000000000e-03 7.271198518019e-01
+ 3.135000000000e-03 3.750679840783e-01
+ 3.136000000000e-03 9.257891024993e-02
+ 3.137000000000e-03 3.694401055608e-02
+ 3.138000000000e-03 2.391410854607e-01
+ 3.139000000000e-03 5.865857558193e-01
+ 3.140000000000e-03 8.858190286279e-01
+ 3.141000000000e-03 9.702262668823e-01
+ 3.142000000000e-03 7.928090829023e-01
+ 3.143000000000e-03 4.523542841498e-01
+ 3.144000000000e-03 1.384288668951e-01
+ 3.145000000000e-03 2.582813030853e-02
+ 3.146000000000e-03 1.772487480476e-01
+ 3.147000000000e-03 5.083789354546e-01
+ 3.148000000000e-03 8.348436881784e-01
+ 3.149000000000e-03 9.748657400779e-01
+ 3.150000000000e-03 8.504800870246e-01
+ 3.151000000000e-03 5.309453052376e-01
+ 3.152000000000e-03 1.941800171274e-01
+ 3.153000000000e-03 2.769688031930e-02
+ 3.154000000000e-03 1.241945681465e-01
+ 3.155000000000e-03 4.299426679509e-01
+ 3.156000000000e-03 7.746990532954e-01
+ 3.157000000000e-03 9.665015822034e-01
+ 3.158000000000e-03 8.985536126085e-01
+ 3.159000000000e-03 6.086889261051e-01
+ 3.160000000000e-03 2.583056822922e-01
+ 3.161000000000e-03 4.249908710158e-02
+ 3.162000000000e-03 8.143137110107e-02
+ 3.163000000000e-03 3.534248368028e-01
+ 3.164000000000e-03 7.070321129629e-01
+ 3.165000000000e-03 9.453628357314e-01
+ 3.166000000000e-03 9.357132235790e-01
+ 3.167000000000e-03 6.834562305591e-01
+ 3.168000000000e-03 3.290498576460e-01
+ 3.169000000000e-03 6.982940990362e-02
+ 3.170000000000e-03 5.013017598233e-02
+ 3.171000000000e-03 2.809207914162e-01
+ 3.172000000000e-03 6.336958455146e-01
+ 3.173000000000e-03 9.120283599840e-01
+ 3.174000000000e-03 9.609413483766e-01
+ 3.175000000000e-03 7.531998052756e-01
+ 3.176000000000e-03 4.044752984502e-01
+ 3.177000000000e-03 1.089394404814e-01
+ 3.178000000000e-03 3.114812862974e-02
+ 3.179000000000e-03 2.144159684689e-01
+ 3.180000000000e-03 5.566984770350e-01
+ 3.181000000000e-03 8.674109797618e-01
+ 3.182000000000e-03 9.735471449384e-01
+ 3.183000000000e-03 8.160098057691e-01
+ 3.184000000000e-03 4.825165691031e-01
+ 3.185000000000e-03 1.587581973639e-01
+ 3.186000000000e-03 2.500502973608e-02
+ 3.187000000000e-03 1.557315230981e-01
+ 3.188000000000e-03 4.781484884877e-01
+ 3.189000000000e-03 8.127324887274e-01
+ 3.190000000000e-03 9.731854185829e-01
+ 3.191000000000e-03 8.701662552020e-01
+ 3.192000000000e-03 5.610366026272e-01
+ 3.193000000000e-03 2.179214534021e-01
+ 3.194000000000e-03 3.186910072675e-02
+ 3.195000000000e-03 1.064744587424e-01
+ 3.196000000000e-03 4.001968774818e-01
+ 3.197000000000e-03 7.494901920447e-01
+ 3.198000000000e-03 9.598660747545e-01
+ 3.199000000000e-03 9.141861438957e-01
+ 3.200000000000e-03 6.378852216961e-01
+ 3.201000000000e-03 2.848090934990e-01
+ 3.202000000000e-03 5.155237721667e-02
+ 3.203000000000e-03 6.799362127192e-02
+ 3.204000000000e-03 3.249782557721e-01
+ 3.205000000000e-03 6.794159044663e-01
+ 3.206000000000e-03 9.339538477739e-01
+ 3.207000000000e-03 9.468640397798e-01
+ 3.208000000000e-03 7.109580186711e-01
+ 3.209000000000e-03 3.575894795272e-01
+ 3.210000000000e-03 8.351585619073e-02
+ 3.211000000000e-03 4.134276245604e-02
+ 3.212000000000e-03 2.545523954665e-01
+ 3.213000000000e-03 6.044285266542e-01
+ 3.214000000000e-03 8.961583130252e-01
+ 3.215000000000e-03 9.673050977088e-01
+ 3.216000000000e-03 7.782539822920e-01
+ 3.217000000000e-03 4.342696075508e-01
+ 3.218000000000e-03 1.268842559571e-01
+ 3.219000000000e-03 2.725168422914e-02
+ 3.220000000000e-03 1.908478246265e-01
+ 3.221000000000e-03 5.265814983787e-01
+ 3.222000000000e-03 8.475144560813e-01
+ 3.223000000000e-03 9.749495637279e-01
+ 3.224000000000e-03 8.379302929791e-01
+ 3.225000000000e-03 5.127496838572e-01
+ 3.226000000000e-03 1.804699846915e-01
+ 3.227000000000e-03 2.610625393688e-02
+ 3.228000000000e-03 1.356090168304e-01
+ 3.229000000000e-03 4.480065675212e-01
+ 3.230000000000e-03 7.893543308597e-01
+ 3.231000000000e-03 9.695881032664e-01
+ 3.232000000000e-03 8.883527862470e-01
+ 3.233000000000e-03 5.908806253007e-01
+ 3.234000000000e-03 2.428056612200e-01
+ 3.235000000000e-03 3.793783781956e-02
+ 3.236000000000e-03 9.034862084712e-02
+ 3.237000000000e-03 3.708554147065e-01
+ 3.238000000000e-03 7.232705829182e-01
+ 3.239000000000e-03 9.513675335148e-01
+ 3.240000000000e-03 9.281407023469e-01
+ 3.241000000000e-03 6.665229093761e-01
+ 3.242000000000e-03 3.121842975001e-01
+ 3.243000000000e-03 6.242244208533e-02
+ 3.244000000000e-03 5.630603855793e-02
+ 3.245000000000e-03 2.972407320985e-01
+ 3.246000000000e-03 6.510728367577e-01
+ 3.247000000000e-03 9.207868030116e-01
+ 3.248000000000e-03 9.562044967224e-01
+ 3.249000000000e-03 7.376051624883e-01
+ 3.250000000000e-03 3.867060424492e-01
+ 3.251000000000e-03 9.888958509296e-02
+ 3.252000000000e-03 3.441348541510e-02
+ 3.253000000000e-03 2.291783698480e-01
+ 3.254000000000e-03 5.747381414177e-01
+ 3.255000000000e-03 8.786833285332e-01
+ 3.256000000000e-03 9.717756758866e-01
+ 3.257000000000e-03 8.021808820423e-01
+ 3.258000000000e-03 4.643302070973e-01
+ 3.259000000000e-03 1.463406576907e-01
+ 3.260000000000e-03 2.527046283615e-02
+ 3.261000000000e-03 1.685321344459e-01
+ 3.262000000000e-03 4.963568313486e-01
+ 3.263000000000e-03 8.262100634362e-01
+ 3.264000000000e-03 9.744278416974e-01
+ 3.265000000000e-03 8.584817390936e-01
+ 3.266000000000e-03 5.429311464172e-01
+ 3.267000000000e-03 2.034762689354e-01
+ 3.268000000000e-03 2.912734157312e-02
+ 3.269000000000e-03 1.169627506071e-01
+ 3.270000000000e-03 4.180752851013e-01
+ 3.271000000000e-03 7.648039254064e-01
+ 3.272000000000e-03 9.640883677624e-01
+ 3.273000000000e-03 9.049660019222e-01
+ 3.274000000000e-03 6.203564675730e-01
+ 3.275000000000e-03 2.687318283609e-01
+ 3.276000000000e-03 4.587850560878e-02
+ 3.277000000000e-03 7.588238430912e-02
+ 3.278000000000e-03 3.420371493133e-01
+ 3.279000000000e-03 6.961464481846e-01
+ 3.280000000000e-03 9.410403882247e-01
+ 3.281000000000e-03 9.403607545158e-01
+ 3.282000000000e-03 6.944859706290e-01
+ 3.283000000000e-03 3.403203904192e-01
+ 3.284000000000e-03 7.506524432518e-02
+ 3.285000000000e-03 4.641597231285e-02
+ 3.286000000000e-03 2.703246375067e-01
+ 3.287000000000e-03 6.221177347742e-01
+ 3.288000000000e-03 9.059150444734e-01
+ 3.289000000000e-03 9.636967538531e-01
+ 3.290000000000e-03 7.632897076905e-01
+ 3.291000000000e-03 4.162815878506e-01
+ 3.292000000000e-03 1.158883137458e-01
+ 3.293000000000e-03 2.937041711363e-02
+ 3.294000000000e-03 2.049015111572e-01
+ 3.295000000000e-03 5.447449730652e-01
+ 3.296000000000e-03 8.596742020905e-01
+ 3.297000000000e-03 9.743349714669e-01
+ 3.298000000000e-03 8.248835706038e-01
+ 3.299000000000e-03 4.945353139977e-01
+ 3.300000000000e-03 1.672298228771e-01
+ 3.301000000000e-03 2.521249087976e-02
+ 3.302000000000e-03 1.475593044325e-01
+ 3.303000000000e-03 4.661469237162e-01
+ 3.304000000000e-03 8.035841113101e-01
+ 3.305000000000e-03 9.719840924751e-01
+ 3.306000000000e-03 8.775808850061e-01
+ 3.307000000000e-03 5.729386840435e-01
+ 3.308000000000e-03 2.276838458187e-01
+ 3.309000000000e-03 3.405605345460e-02
+ 3.310000000000e-03 9.986826516944e-02
+ 3.311000000000e-03 3.884759004240e-01
+ 3.312000000000e-03 7.391807322696e-01
+ 3.313000000000e-03 9.567084928907e-01
+ 3.314000000000e-03 9.199385978886e-01
+ 3.315000000000e-03 6.493447153514e-01
+ 3.316000000000e-03 2.955949213636e-01
+ 3.317000000000e-03 5.565893444060e-02
+ 3.318000000000e-03 6.313435551160e-02
+ 3.319000000000e-03 3.138588313847e-01
+ 3.320000000000e-03 6.682276745745e-01
+ 3.321000000000e-03 9.289264767619e-01
+ 3.322000000000e-03 9.507967938801e-01
+ 3.323000000000e-03 7.216611200199e-01
+ 3.324000000000e-03 3.691033858275e-01
+ 3.325000000000e-03 8.942956474638e-02
+ 3.326000000000e-03 3.836348969685e-02
+ 3.327000000000e-03 2.443390159040e-01
+ 3.328000000000e-03 5.926679029576e-01
+ 3.329000000000e-03 8.893988214151e-01
+ 3.330000000000e-03 9.693104581431e-01
+ 3.331000000000e-03 7.879075996886e-01
+ 3.332000000000e-03 4.461962977158e-01
+ 3.333000000000e-03 1.344431759995e-01
+ 3.334000000000e-03 2.623398829688e-02
+ 3.335000000000e-03 1.818201710888e-01
+ 3.336000000000e-03 5.145705315087e-01
+ 3.337000000000e-03 8.392079444764e-01
+ 3.338000000000e-03 9.749726160961e-01
+ 3.339000000000e-03 8.462700736424e-01
+ 3.340000000000e-03 5.247625597234e-01
+ 3.341000000000e-03 1.894671242244e-01
+ 3.342000000000e-03 2.707800321903e-02
+ 3.343000000000e-03 1.280143008258e-01
+ 3.344000000000e-03 4.360741634588e-01
+ 3.345000000000e-03 7.797282631585e-01
+ 3.346000000000e-03 9.676282163070e-01
+ 3.347000000000e-03 8.951503552453e-01
+ 3.348000000000e-03 6.026507286113e-01
+ 3.349000000000e-03 2.529946443240e-01
+ 3.350000000000e-03 4.087242212283e-02
+ 3.351000000000e-03 8.439481460172e-02
+ 3.352000000000e-03 3.593283280841e-01
+ 3.353000000000e-03 7.125885574863e-01
+ 3.354000000000e-03 9.474783763912e-01
+ 3.355000000000e-03 9.332099163725e-01
+ 3.356000000000e-03 6.777279299114e-01
+ 3.357000000000e-03 3.232861110438e-01
+ 3.358000000000e-03 6.723950132389e-02
+ 3.359000000000e-03 5.215617994396e-02
+ 3.360000000000e-03 2.864346184138e-01
+ 3.361000000000e-03 6.396273681021e-01
+ 3.362000000000e-03 9.150748756460e-01
+ 3.363000000000e-03 9.594065414045e-01
+ 3.364000000000e-03 7.479382641452e-01
+ 3.365000000000e-03 3.984166765296e-01
+ 3.366000000000e-03 1.054572098535e-01
+ 3.367000000000e-03 3.218121335375e-02
+ 3.368000000000e-03 2.193891416169e-01
+ 3.369000000000e-03 5.628426500260e-01
+ 3.370000000000e-03 8.713050452336e-01
+ 3.371000000000e-03 9.730228670563e-01
+ 3.372000000000e-03 8.113591051750e-01
+ 3.373000000000e-03 4.763289799887e-01
+ 3.374000000000e-03 1.544790014140e-01
+ 3.375000000000e-03 2.501690543139e-02
+ 3.376000000000e-03 1.600278579900e-01
+ 3.377000000000e-03 4.843370610435e-01
+ 3.378000000000e-03 8.173674696776e-01
+ 3.379000000000e-03 9.736860265145e-01
+ 3.380000000000e-03 8.662537490245e-01
+ 3.381000000000e-03 5.548894860557e-01
+ 3.382000000000e-03 2.129624727997e-01
+ 3.383000000000e-03 3.085944219165e-02
+ 3.384000000000e-03 1.099763053792e-01
+ 3.385000000000e-03 4.062603829354e-01
+ 3.386000000000e-03 7.547391650562e-01
+ 3.387000000000e-03 9.613778599494e-01
+ 3.388000000000e-03 9.111189714431e-01
+ 3.389000000000e-03 6.319469091123e-01
+ 3.390000000000e-03 2.793061240047e-01
+ 3.391000000000e-03 4.954883274413e-02
+ 3.392000000000e-03 7.060508576636e-02
+ 3.393000000000e-03 3.307506522694e-01
+ 3.394000000000e-03 6.851351326830e-01
+ 3.395000000000e-03 9.364354118005e-01
+ 3.396000000000e-03 9.447261919060e-01
+ 3.397000000000e-03 7.053911236720e-01
+ 3.398000000000e-03 3.516932133872e-01
+ 3.399000000000e-03 8.057329045292e-02
+ 3.400000000000e-03 4.299233297218e-02
+ 3.401000000000e-03 2.598756128248e-01
+ 3.402000000000e-03 6.104613958431e-01
+ 3.403000000000e-03 8.995417012167e-01
+ 3.404000000000e-03 9.661551168241e-01
+ 3.405000000000e-03 7.732109476472e-01
+ 3.406000000000e-03 4.281415069704e-01
+ 3.407000000000e-03 1.230832476019e-01
+ 3.408000000000e-03 2.789418924886e-02
+ 3.409000000000e-03 1.955760928967e-01
+ 3.410000000000e-03 5.327628056232e-01
+ 3.411000000000e-03 8.517070183934e-01
+ 3.412000000000e-03 9.748189406852e-01
+ 3.413000000000e-03 8.335492161688e-01
+ 3.414000000000e-03 5.065575595509e-01
+ 3.415000000000e-03 1.759146197924e-01
+ 3.416000000000e-03 2.572409922770e-02
+ 3.417000000000e-03 1.396128580337e-01
+ 3.418000000000e-03 4.541670451061e-01
+ 3.419000000000e-03 7.942412589817e-01
+ 3.420000000000e-03 9.704804150218e-01
+ 3.421000000000e-03 8.847536378264e-01
+ 3.422000000000e-03 5.847940411962e-01
+ 3.423000000000e-03 2.376206830033e-01
+ 3.424000000000e-03 3.654148823174e-02
+ 3.425000000000e-03 9.351839457485e-02
+ 3.426000000000e-03 3.768263653117e-01
+ 3.427000000000e-03 7.287180541606e-01
+ 3.428000000000e-03 9.532583451768e-01
+ 3.429000000000e-03 9.254220406963e-01
+ 3.430000000000e-03 6.607085393089e-01
+ 3.431000000000e-03 3.065116904008e-01
+ 3.432000000000e-03 6.005013498441e-02
+ 3.433000000000e-03 5.855494434275e-02
+ 3.434000000000e-03 3.028586483738e-01
+ 3.435000000000e-03 6.569316786276e-01
+ 3.436000000000e-03 9.236243369613e-01
+ 3.437000000000e-03 9.544407691437e-01
+ 3.438000000000e-03 7.322222260372e-01
+ 3.439000000000e-03 3.807011440372e-01
+ 3.440000000000e-03 9.560628327508e-02
+ 3.441000000000e-03 3.567993965839e-02
+ 3.442000000000e-03 2.342894118668e-01
+ 3.443000000000e-03 5.808479165288e-01
+ 3.444000000000e-03 8.823898822928e-01
+ 3.445000000000e-03 9.710151799527e-01
+ 3.446000000000e-03 7.973767844922e-01
+ 3.447000000000e-03 4.581574543428e-01
+ 3.448000000000e-03 1.422362704545e-01
+ 3.449000000000e-03 2.551978520122e-02
+ 3.450000000000e-03 1.729963424275e-01
+ 3.451000000000e-03 5.025502308076e-01
+ 3.452000000000e-03 8.306841374582e-01
+ 3.453000000000e-03 9.746914026812e-01
+ 3.454000000000e-03 8.543880349174e-01
+ 3.455000000000e-03 5.367595727809e-01
+ 3.456000000000e-03 1.986631900224e-01
+ 3.457000000000e-03 2.835270466483e-02
+ 3.458000000000e-03 1.206578775484e-01
+ 3.459000000000e-03 4.241827100622e-01
+ 3.460000000000e-03 7.699230025182e-01
+ 3.461000000000e-03 9.653687683611e-01
+ 3.462000000000e-03 9.016947923191e-01
+ 3.463000000000e-03 6.143550742273e-01
+ 3.464000000000e-03 2.633418581881e-01
+ 3.465000000000e-03 4.410112193362e-02
+ 3.466000000000e-03 7.870724357257e-02
+ 3.467000000000e-03 3.478913552387e-01
+ 3.468000000000e-03 7.017703485741e-01
+ 3.469000000000e-03 9.433025661974e-01
+ 3.470000000000e-03 9.380016176531e-01
+ 3.471000000000e-03 6.888190985619e-01
+ 3.472000000000e-03 3.345011268816e-01
+ 3.473000000000e-03 7.233378541191e-02
+ 3.474000000000e-03 4.829320850196e-02
+ 3.475000000000e-03 2.757653139597e-01
+ 3.476000000000e-03 6.280924546470e-01
+ 3.477000000000e-03 9.090970527785e-01
+ 3.478000000000e-03 9.623142918760e-01
+ 3.479000000000e-03 7.581125374246e-01
+ 3.480000000000e-03 4.101923845291e-01
+ 3.481000000000e-03 1.122775773341e-01
+ 3.482000000000e-03 3.024862435757e-02
+ 3.483000000000e-03 2.097796717122e-01
+ 3.484000000000e-03 5.509069018542e-01
+ 3.485000000000e-03 8.636889052312e-01
+ 3.486000000000e-03 9.739670414453e-01
+ 3.487000000000e-03 8.203378727627e-01
+ 3.488000000000e-03 4.883429164517e-01
+ 3.489000000000e-03 1.628386846706e-01
+ 3.490000000000e-03 2.506762052224e-02
+ 3.491000000000e-03 1.517413664897e-01
+ 3.492000000000e-03 4.723273243621e-01
+ 3.493000000000e-03 8.083215714367e-01
+ 3.494000000000e-03 9.726407697331e-01
+ 3.495000000000e-03 8.737911380951e-01
+ 3.496000000000e-03 5.668126636833e-01
+ 3.497000000000e-03 2.226325518921e-01
+ 3.498000000000e-03 3.289207259730e-02
+ 3.499000000000e-03 1.032397079547e-01
+ 3.500000000000e-03 3.945055300375e-01
+ 3.501000000000e-03 7.445112196951e-01
+ 3.502000000000e-03 9.583717951061e-01
+ 3.503000000000e-03 9.170085796004e-01
+ 3.504000000000e-03 6.434528259269e-01
+ 3.505000000000e-03 2.900217953673e-01
+ 3.506000000000e-03 5.350771730888e-02
+ 3.507000000000e-03 6.560285609144e-02
+ 3.508000000000e-03 3.195725757610e-01
+ 3.509000000000e-03 6.740052202683e-01
+ 3.510000000000e-03 9.315508563902e-01
+ 3.511000000000e-03 9.488067392656e-01
+ 3.512000000000e-03 7.161647038852e-01
+ 3.513000000000e-03 3.631610411600e-01
+ 3.514000000000e-03 8.635001985181e-02
+ 3.515000000000e-03 3.986145113154e-02
+ 3.516000000000e-03 2.495804109786e-01
+ 3.517000000000e-03 5.987342957317e-01
+ 3.518000000000e-03 8.929124129549e-01
+ 3.519000000000e-03 9.683148624708e-01
+ 3.520000000000e-03 7.829571696341e-01
+ 3.521000000000e-03 4.400474583878e-01
+ 3.522000000000e-03 1.305196330006e-01
+ 3.523000000000e-03 2.672039070183e-02
+ 3.524000000000e-03 1.864456875179e-01
+ 3.525000000000e-03 5.207596504437e-01
+ 3.526000000000e-03 8.435145324205e-01
+ 3.527000000000e-03 9.749987425643e-01
+ 3.528000000000e-03 8.420011912818e-01
+ 3.529000000000e-03 5.185756043548e-01
+ 3.530000000000e-03 1.848070246594e-01
+ 3.531000000000e-03 2.653952704538e-02
+ 3.532000000000e-03 1.318972743673e-01
+ 3.533000000000e-03 4.422165269252e-01
+ 3.534000000000e-03 7.847099167401e-01
+ 3.535000000000e-03 9.686753494735e-01
+ 3.536000000000e-03 8.916799188230e-01
+ 3.537000000000e-03 5.965950795851e-01
+ 3.538000000000e-03 2.477255994532e-01
+ 3.539000000000e-03 3.932381289733e-02
+ 3.540000000000e-03 8.742891466346e-02
+ 3.541000000000e-03 3.652557347954e-01
+ 3.542000000000e-03 7.181088600728e-01
+ 3.543000000000e-03 9.495178417651e-01
+ 3.544000000000e-03 9.306329596446e-01
+ 3.545000000000e-03 6.719694139425e-01
+ 3.546000000000e-03 3.175524073671e-01
+ 3.547000000000e-03 6.472316586041e-02
+ 3.548000000000e-03 5.425832131996e-02
+ 3.549000000000e-03 2.919847534174e-01
+ 3.550000000000e-03 6.455351528010e-01
+ 3.551000000000e-03 9.180508249041e-01
+ 3.552000000000e-03 9.577936312528e-01
+ 3.553000000000e-03 7.426345713149e-01
+ 3.554000000000e-03 3.923753246736e-01
+ 3.555000000000e-03 1.020420549928e-01
+ 3.556000000000e-03 3.329383141341e-02
+ 3.557000000000e-03 2.244100210953e-01
+ 3.558000000000e-03 5.689761392100e-01
+ 3.559000000000e-03 8.751359855602e-01
+ 3.560000000000e-03 9.724181710988e-01
+ 3.561000000000e-03 8.066554707761e-01
+ 3.562000000000e-03 4.701454151574e-01
+ 3.563000000000e-03 1.502585470929e-01
+ 3.564000000000e-03 2.510953245817e-02
+ 3.565000000000e-03 1.643819911561e-01
+ 3.566000000000e-03 4.905282964378e-01
+ 3.567000000000e-03 8.219484953478e-01
+ 3.568000000000e-03 9.741061036276e-01
+ 3.569000000000e-03 8.622789764669e-01
+ 3.570000000000e-03 5.487330377859e-01
+ 3.571000000000e-03 2.080522911183e-01
+ 3.572000000000e-03 2.992954170502e-02
+ 3.573000000000e-03 1.135444594971e-01
+ 3.574000000000e-03 4.123398249541e-01
+ 3.575000000000e-03 7.599448301543e-01
+ 3.576000000000e-03 9.628112068231e-01
+ 3.577000000000e-03 9.079819051253e-01
+ 3.578000000000e-03 6.259861643857e-01
+ 3.579000000000e-03 2.738406744233e-01
+ 3.580000000000e-03 4.762186895816e-02
+ 3.581000000000e-03 7.328955119781e-02
+ 3.582000000000e-03 3.365518226546e-01
+ 3.583000000000e-03 6.908228862881e-01
+ 3.584000000000e-03 9.388427779428e-01
+ 3.585000000000e-03 9.425127366419e-01
+ 3.586000000000e-03 6.997893103632e-01
+ 3.587000000000e-03 3.458221607143e-01
+ 3.588000000000e-03 7.770203096905e-02
+ 3.589000000000e-03 4.471959883789e-02
+ 3.590000000000e-03 2.652396534547e-01
+ 3.591000000000e-03 6.164754856171e-01
+ 3.592000000000e-03 9.028571637814e-01
+ 3.593000000000e-03 9.649258854422e-01
+ 3.594000000000e-03 7.681214647223e-01
+ 3.595000000000e-03 4.220256229703e-01
+ 3.596000000000e-03 1.193463184316e-01
+ 3.597000000000e-03 2.861695643633e-02
+ 3.598000000000e-03 2.003561159262e-01
+ 3.599000000000e-03 5.389385429009e-01
+ 3.600000000000e-03 8.558397873985e-01
+ 3.601000000000e-03 9.746075942187e-01
+ 3.602000000000e-03 8.291114330384e-01
+ 3.603000000000e-03 5.003643204016e-01
+ 3.604000000000e-03 1.714143522772e-01
+ 3.605000000000e-03 2.542257562078e-02
+ 3.606000000000e-03 1.436779682419e-01
+ 3.607000000000e-03 4.603353146992e-01
+ 3.608000000000e-03 7.990781634844e-01
+ 3.609000000000e-03 9.712927409411e-01
+ 3.610000000000e-03 8.810890778807e-01
+ 3.611000000000e-03 5.786930413541e-01
+ 3.612000000000e-03 2.324803115937e-01
+ 3.613000000000e-03 3.522393069423e-02
+ 3.614000000000e-03 9.675727377440e-02
+ 3.615000000000e-03 3.828182565253e-01
+ 3.616000000000e-03 7.341266413090e-01
+ 3.617000000000e-03 9.550720989070e-01
+ 3.618000000000e-03 9.226310535320e-01
+ 3.619000000000e-03 6.548668473668e-01
+ 3.620000000000e-03 3.008719780277e-01
+ 3.621000000000e-03 5.775262325567e-02
+ 3.622000000000e-03 6.087889969541e-02
+ 3.623000000000e-03 3.085100804241e-01
+ 3.624000000000e-03 6.627638407232e-01
+ 3.625000000000e-03 9.263898510229e-01
+ 3.626000000000e-03 9.525997826107e-01
+ 3.627000000000e-03 7.267998097512e-01
+ 3.628000000000e-03 3.747165274872e-01
+ 3.629000000000e-03 9.239173196946e-02
+ 3.630000000000e-03 3.702533242293e-02
+ 3.631000000000e-03 2.394456270378e-01
+ 3.632000000000e-03 5.869439467786e-01
+ 3.633000000000e-03 8.860314263868e-01
+ 3.634000000000e-03 9.701746072680e-01
+ 3.635000000000e-03 7.925221302557e-01
+ 3.636000000000e-03 4.519918151916e-01
+ 3.637000000000e-03 1.381927062197e-01
+ 3.638000000000e-03 2.584977340376e-02
+ 3.639000000000e-03 1.775161439259e-01
+ 3.640000000000e-03 5.087431967050e-01
+ 3.641000000000e-03 8.351019922493e-01
+ 3.642000000000e-03 9.748742619238e-01
+ 3.643000000000e-03 8.502340816375e-01
+ 3.644000000000e-03 5.305817496920e-01
+ 3.645000000000e-03 1.939013410352e-01
+ 3.646000000000e-03 2.765825197261e-02
+ 3.647000000000e-03 1.244174960090e-01
+ 3.648000000000e-03 4.303030246336e-01
+ 3.649000000000e-03 7.749961903299e-01
+ 3.650000000000e-03 9.665700521490e-01
+ 3.651000000000e-03 8.983552910446e-01
+ 3.652000000000e-03 6.083342395063e-01
+ 3.653000000000e-03 2.579921219948e-01
+ 3.654000000000e-03 4.240124510410e-02
+ 3.655000000000e-03 8.160372633473e-02
+ 3.656000000000e-03 3.537714209801e-01
+ 3.657000000000e-03 7.073599462181e-01
+ 3.658000000000e-03 9.454893788089e-01
+ 3.659000000000e-03 9.355680166376e-01
+ 3.660000000000e-03 6.831201255761e-01
+ 3.661000000000e-03 3.287099996179e-01
+ 3.662000000000e-03 6.967503354158e-02
+ 3.663000000000e-03 5.024723884493e-02
+ 3.664000000000e-03 2.812441122946e-01
+ 3.665000000000e-03 6.340453976685e-01
+ 3.666000000000e-03 9.122095109625e-01
+ 3.667000000000e-03 9.608532323761e-01
+ 3.668000000000e-03 7.528914857418e-01
+ 3.669000000000e-03 4.041184492973e-01
+ 3.670000000000e-03 1.087327571671e-01
+ 3.671000000000e-03 3.120669349447e-02
+ 3.672000000000e-03 2.147071722925e-01
+ 3.673000000000e-03 5.570601760194e-01
+ 3.674000000000e-03 8.676417780381e-01
+ 3.675000000000e-03 9.735185328302e-01
+ 3.676000000000e-03 8.157377146466e-01
+ 3.677000000000e-03 4.821525007133e-01
+ 3.678000000000e-03 1.585048668731e-01
+ 3.679000000000e-03 2.500349287416e-02
+ 3.680000000000e-03 1.559826355979e-01
+ 3.681000000000e-03 4.785124296078e-01
+ 3.682000000000e-03 8.130066141664e-01
+ 3.683000000000e-03 9.732170938756e-01
+ 3.684000000000e-03 8.699378433813e-01
+ 3.685000000000e-03 5.606752845785e-01
+ 3.686000000000e-03 2.176284128874e-01
+ 3.687000000000e-03 3.180750422330e-02
+ 3.688000000000e-03 1.066786035025e-01
+ 3.689000000000e-03 4.005530946448e-01
+ 3.690000000000e-03 7.498001380486e-01
+ 3.691000000000e-03 9.599571700579e-01
+ 3.692000000000e-03 9.140076661617e-01
+ 3.693000000000e-03 6.375365482517e-01
+ 3.694000000000e-03 2.844843675251e-01
+ 3.695000000000e-03 5.143240781843e-02
+ 3.696000000000e-03 6.814520803189e-02
+ 3.697000000000e-03 3.253169943966e-01
+ 3.698000000000e-03 6.797531835341e-01
+ 3.699000000000e-03 9.341018685520e-01
+ 3.700000000000e-03 9.467403835319e-01
+ 3.701000000000e-03 7.106315378367e-01
+ 3.702000000000e-03 3.572419603269e-01
+ 3.703000000000e-03 8.334079911623e-02
+ 3.704000000000e-03 4.143764019356e-02
+ 3.705000000000e-03 2.548643796001e-01
+ 3.706000000000e-03 6.047839028015e-01
+ 3.707000000000e-03 8.963592059058e-01
+ 3.708000000000e-03 9.672396491256e-01
+ 3.709000000000e-03 7.779586343554e-01
+ 3.710000000000e-03 4.339088115224e-01
+ 3.711000000000e-03 1.266589049354e-01
+ 3.712000000000e-03 2.728725483070e-02
+ 3.713000000000e-03 1.911245109561e-01
+ 3.714000000000e-03 5.269452400540e-01
+ 3.715000000000e-03 8.477627198528e-01
+ 3.716000000000e-03 9.749441150408e-01
+ 3.717000000000e-03 8.376741656906e-01
+ 3.718000000000e-03 5.123854909689e-01
+ 3.719000000000e-03 1.802005106911e-01
+ 3.720000000000e-03 2.608154334402e-02
+ 3.721000000000e-03 1.358428286314e-01
+ 3.722000000000e-03 4.483687140936e-01
+ 3.723000000000e-03 7.896431671152e-01
+ 3.724000000000e-03 9.696428036811e-01
+ 3.725000000000e-03 8.881428933467e-01
+ 3.726000000000e-03 5.905230085398e-01
+ 3.727000000000e-03 2.424994434643e-01
+ 3.728000000000e-03 3.785352270241e-02
+ 3.729000000000e-03 9.053315546263e-02
+ 3.730000000000e-03 3.712060492245e-01
+ 3.731000000000e-03 7.235920822220e-01
+ 3.732000000000e-03 9.514808851259e-01
+ 3.733000000000e-03 9.279827915010e-01
+ 3.734000000000e-03 6.661816616504e-01
+ 3.735000000000e-03 3.118497213965e-01
+ 3.736000000000e-03 6.228083131266e-02
+ 3.737000000000e-03 5.643624272791e-02
+ 3.738000000000e-03 2.975702528546e-01
+ 3.739000000000e-03 6.514181952353e-01
+ 3.740000000000e-03 9.209557018206e-01
+ 3.741000000000e-03 9.561028921307e-01
+ 3.742000000000e-03 7.372896284591e-01
+ 3.743000000000e-03 3.863522699651e-01
+ 3.744000000000e-03 9.869455650650e-02
+ 3.745000000000e-03 3.448579365389e-02
+ 3.746000000000e-03 2.294777533100e-01
+ 3.747000000000e-03 5.750979018395e-01
+ 3.748000000000e-03 8.789031494481e-01
+ 3.749000000000e-03 9.717331598695e-01
+ 3.750000000000e-03 8.018997022323e-01
+ 3.751000000000e-03 4.639669258694e-01
+ 3.752000000000e-03 1.460975519155e-01
+ 3.753000000000e-03 2.528289506900e-02
+ 3.754000000000e-03 1.687931823552e-01
+ 3.755000000000e-03 4.967211421054e-01
+ 3.756000000000e-03 8.264747869235e-01
+ 3.757000000000e-03 9.744455785054e-01
+ 3.758000000000e-03 8.582426132758e-01
+ 3.759000000000e-03 5.425683044679e-01
+ 3.760000000000e-03 2.031917431325e-01
+ 3.761000000000e-03 2.907955735819e-02
+ 3.762000000000e-03 1.171783144786e-01
+ 3.763000000000e-03 4.184341699784e-01
+ 3.764000000000e-03 7.651063023296e-01
+ 3.765000000000e-03 9.641658716941e-01
+ 3.766000000000e-03 9.047754782715e-01
+ 3.767000000000e-03 6.200040008958e-01
+ 3.768000000000e-03 2.684136739297e-01
+ 3.769000000000e-03 4.577181345977e-02
+ 3.770000000000e-03 7.604656118364e-02
+ 3.771000000000e-03 3.423807806769e-01
+ 3.772000000000e-03 6.964781983130e-01
+ 3.773000000000e-03 9.411755369275e-01
+ 3.774000000000e-03 9.402240502947e-01
+ 3.775000000000e-03 6.941535311027e-01
+ 3.776000000000e-03 3.399773196389e-01
+ 3.777000000000e-03 7.490256587903e-02
+ 3.778000000000e-03 4.652426640281e-02
+ 3.779000000000e-03 2.706436054222e-01
+ 3.780000000000e-03 6.224697735268e-01
+ 3.781000000000e-03 9.061041370616e-01
+ 3.782000000000e-03 9.636176125436e-01
+ 3.783000000000e-03 7.629863987748e-01
+ 3.784000000000e-03 4.159229953043e-01
+ 3.785000000000e-03 1.156741037575e-01
+ 3.786000000000e-03 2.941986291470e-02
+ 3.787000000000e-03 2.051870810693e-01
+ 3.788000000000e-03 5.451076602813e-01
+ 3.789000000000e-03 8.599120604893e-01
+ 3.790000000000e-03 9.743155602591e-01
+ 3.791000000000e-03 8.246176980507e-01
+ 3.792000000000e-03 4.941710193144e-01
+ 3.793000000000e-03 1.669699472313e-01
+ 3.794000000000e-03 2.520173437780e-02
+ 3.795000000000e-03 1.478036563504e-01
+ 3.796000000000e-03 4.665103276397e-01
+ 3.797000000000e-03 8.038642220515e-01
+ 3.798000000000e-03 9.720249429218e-01
+ 3.799000000000e-03 8.773597294178e-01
+ 3.800000000000e-03 5.725786629980e-01
+ 3.801000000000e-03 2.273854208995e-01
+ 3.802000000000e-03 3.398538920357e-02
+ 3.803000000000e-03 1.000647078076e-01
+ 3.804000000000e-03 3.888300696725e-01
+ 3.805000000000e-03 7.394954248553e-01
+ 3.806000000000e-03 9.568084863513e-01
+ 3.807000000000e-03 9.197682153469e-01
+ 3.808000000000e-03 6.489988266896e-01
+ 3.809000000000e-03 2.952661191811e-01
+ 3.810000000000e-03 5.553029749654e-02
+ 3.811000000000e-03 6.327750952309e-02
+ 3.812000000000e-03 3.141940674563e-01
+ 3.813000000000e-03 6.685683315243e-01
+ 3.814000000000e-03 9.290828750348e-01
+ 3.815000000000e-03 9.506818501073e-01
+ 3.816000000000e-03 7.213388354900e-01
+ 3.817000000000e-03 3.687532102366e-01
+ 3.818000000000e-03 8.924647767838e-02
+ 3.819000000000e-03 3.844943497998e-02
+ 3.820000000000e-03 2.446461387593e-01
+ 3.821000000000e-03 5.930251957874e-01
+ 3.822000000000e-03 8.896073417204e-01
+ 3.823000000000e-03 9.692541007372e-01
+ 3.824000000000e-03 7.876177446673e-01
+ 3.825000000000e-03 4.458343378568e-01
+ 3.826000000000e-03 1.342106524282e-01
+ 3.827000000000e-03 2.626037134282e-02
+ 3.828000000000e-03 1.820907705352e-01
+ 3.829000000000e-03 5.149346761816e-01
+ 3.830000000000e-03 8.394628767347e-01
+ 3.831000000000e-03 9.749763883373e-01
+ 3.832000000000e-03 8.460205854630e-01
+ 3.833000000000e-03 5.243987274346e-01
+ 3.834000000000e-03 1.891915315301e-01
+ 3.835000000000e-03 2.704410155958e-02
+ 3.836000000000e-03 1.282409668209e-01
+ 3.837000000000e-03 4.364351883077e-01
+ 3.838000000000e-03 7.800226263543e-01
+ 3.839000000000e-03 9.676920148970e-01
+ 3.840000000000e-03 8.949480658439e-01
+ 3.841000000000e-03 6.022949870057e-01
+ 3.842000000000e-03 2.526835292834e-01
+ 3.843000000000e-03 4.077916411444e-02
+ 3.844000000000e-03 8.457134016780e-02
+ 3.845000000000e-03 3.596763468747e-01
+ 3.846000000000e-03 7.129142908353e-01
+ 3.847000000000e-03 9.476004542818e-01
+ 3.848000000000e-03 9.330603652027e-01
+ 3.849000000000e-03 6.773900205477e-01
+ 3.850000000000e-03 3.229479931707e-01
+ 3.851000000000e-03 6.708944072563e-02
+ 3.852000000000e-03 5.227773113924e-02
+ 3.853000000000e-03 2.867601010673e-01
+ 3.854000000000e-03 6.399755517855e-01
+ 3.855000000000e-03 9.152518898800e-01
+ 3.856000000000e-03 9.593138237464e-01
+ 3.857000000000e-03 7.476274402676e-01
+ 3.858000000000e-03 3.980608147780e-01
+ 3.859000000000e-03 1.052544558955e-01
+ 3.860000000000e-03 3.224446164404e-02
+ 3.861000000000e-03 2.196831751796e-01
+ 3.862000000000e-03 5.632037494495e-01
+ 3.863000000000e-03 8.715321484877e-01
+ 3.864000000000e-03 9.729895218722e-01
+ 3.865000000000e-03 8.110838783239e-01
+ 3.866000000000e-03 4.759651192077e-01
+ 3.867000000000e-03 1.542291062716e-01
+ 3.868000000000e-03 2.502011883782e-02
+ 3.869000000000e-03 1.602823907040e-01
+ 3.870000000000e-03 4.847011879308e-01
+ 3.871000000000e-03 8.176384430002e-01
+ 3.872000000000e-03 9.737129669224e-01
+ 3.873000000000e-03 8.660216559588e-01
+ 3.874000000000e-03 5.545275901384e-01
+ 3.875000000000e-03 2.126722795526e-01
+ 3.876000000000e-03 3.080253271888e-02
+ 3.877000000000e-03 1.101843671701e-01
+ 3.878000000000e-03 4.066175661066e-01
+ 3.879000000000e-03 7.550465881668e-01
+ 3.880000000000e-03 9.614643482184e-01
+ 3.881000000000e-03 9.109363677541e-01
+ 3.882000000000e-03 6.315968881456e-01
+ 3.883000000000e-03 2.789835792484e-01
+ 3.884000000000e-03 4.943335879009e-02
+ 3.885000000000e-03 7.076097911052e-02
+ 3.886000000000e-03 3.310911106900e-01
+ 3.887000000000e-03 6.854705871670e-01
+ 3.888000000000e-03 9.365790795527e-01
+ 3.889000000000e-03 9.445980779776e-01
+ 3.890000000000e-03 7.050625625621e-01
+ 3.891000000000e-03 3.513471496246e-01
+ 3.892000000000e-03 8.040241413391e-02
+ 3.893000000000e-03 4.309178891669e-02
+ 3.894000000000e-03 2.601900234476e-01
+ 3.895000000000e-03 6.108156956802e-01
+ 3.896000000000e-03 8.997386142823e-01
+ 3.897000000000e-03 9.660850009032e-01
+ 3.898000000000e-03 7.729128436478e-01
+ 3.899000000000e-03 4.277814007442e-01
+ 3.900000000000e-03 1.228616481618e-01
+ 3.901000000000e-03 2.793448431151e-02
+ 3.902000000000e-03 1.958558459624e-01
+ 3.903000000000e-03 5.331262487352e-01
+ 3.904000000000e-03 8.519517845435e-01
+ 3.905000000000e-03 9.748087428126e-01
+ 3.906000000000e-03 8.332897325018e-01
+ 3.907000000000e-03 5.061932719402e-01
+ 3.908000000000e-03 1.756483654670e-01
+ 3.909000000000e-03 2.570412997626e-02
+ 3.910000000000e-03 1.398502928386e-01
+ 3.911000000000e-03 4.545296790375e-01
+ 3.912000000000e-03 7.945271755873e-01
+ 3.913000000000e-03 9.705304144540e-01
+ 3.914000000000e-03 8.845398801420e-01
+ 3.915000000000e-03 5.844355477817e-01
+ 3.916000000000e-03 2.373170648496e-01
+ 3.917000000000e-03 3.646180150037e-02
+ 3.918000000000e-03 9.370700925069e-02
+ 3.919000000000e-03 3.771782597658e-01
+ 3.920000000000e-03 7.290372917374e-01
+ 3.921000000000e-03 9.533671727390e-01
+ 3.922000000000e-03 9.252598624933e-01
+ 3.923000000000e-03 6.603656570049e-01
+ 3.924000000000e-03 3.061790226394e-01
+ 3.925000000000e-03 5.991291289896e-02
+ 3.926000000000e-03 5.868957390172e-02
+ 3.927000000000e-03 3.031901671412e-01
+ 3.928000000000e-03 6.572754952359e-01
+ 3.929000000000e-03 9.237890125409e-01
+ 3.930000000000e-03 9.543346114787e-01
+ 3.931000000000e-03 7.319043442657e-01
+ 3.932000000000e-03 3.803485363769e-01
+ 3.933000000000e-03 9.541528349851e-02
+ 3.934000000000e-03 3.575689743100e-02
+ 3.935000000000e-03 2.345914767019e-01
+ 3.936000000000e-03 5.812068971608e-01
+ 3.937000000000e-03 8.826058964455e-01
+ 3.938000000000e-03 9.709679498264e-01
+ 3.939000000000e-03 7.970926080660e-01
+ 3.940000000000e-03 4.577945625235e-01
+ 3.941000000000e-03 1.419967232873e-01
+ 3.942000000000e-03 2.553696379071e-02
+ 3.943000000000e-03 1.732606816456e-01
+ 3.944000000000e-03 5.029145452081e-01
+ 3.945000000000e-03 8.309455748947e-01
+ 3.946000000000e-03 9.747043934343e-01
+ 3.947000000000e-03 8.541453456683e-01
+ 3.948000000000e-03 5.363963341613e-01
+ 3.949000000000e-03 1.983816551780e-01
+ 3.950000000000e-03 2.830963365606e-02
+ 3.951000000000e-03 1.208772525359e-01
+ 3.952000000000e-03 4.245423819163e-01
+ 3.953000000000e-03 7.702227040864e-01
+ 3.954000000000e-03 9.654416242572e-01
+ 3.955000000000e-03 9.015002360024e-01
+ 3.956000000000e-03 6.140014356636e-01
+ 3.957000000000e-03 2.630260451619e-01
+ 3.958000000000e-03 4.399898077467e-02
+ 3.959000000000e-03 7.887564700757e-02
+ 3.960000000000e-03 3.482365353621e-01
+ 3.961000000000e-03 7.021001073049e-01
+ 3.962000000000e-03 9.434332921649e-01
+ 3.963000000000e-03 9.378605219614e-01
+ 3.964000000000e-03 6.884847440232e-01
+ 3.965000000000e-03 3.341596838361e-01
+ 3.966000000000e-03 7.217537111644e-02
+ 3.967000000000e-03 4.840602885741e-02
+ 3.968000000000e-03 2.760865500075e-01
+ 3.969000000000e-03 6.284432404908e-01
+ 3.970000000000e-03 9.092820690428e-01
+ 3.971000000000e-03 9.622305205460e-01
+ 3.972000000000e-03 7.578066228108e-01
+ 3.973000000000e-03 4.098346614738e-01
+ 3.974000000000e-03 1.120672278884e-01
+ 3.975000000000e-03 3.030277218284e-02
+ 3.976000000000e-03 2.100681670186e-01
+ 3.977000000000e-03 5.512691089603e-01
+ 3.978000000000e-03 8.639231453431e-01
+ 3.979000000000e-03 9.739428884548e-01
+ 3.980000000000e-03 8.200687751800e-01
+ 3.981000000000e-03 4.879787092056e-01
+ 3.982000000000e-03 1.625821602431e-01
+ 3.983000000000e-03 2.506161304374e-02
+ 3.984000000000e-03 1.519892209554e-01
+ 3.985000000000e-03 4.726910341213e-01
+ 3.986000000000e-03 8.085986210105e-01
+ 3.987000000000e-03 9.726768964830e-01
+ 3.988000000000e-03 8.735662264597e-01
+ 3.989000000000e-03 5.664519456268e-01
+ 3.990000000000e-03 2.223368770975e-01
+ 3.991000000000e-03 3.282607432269e-02
+ 3.992000000000e-03 1.034401343814e-01
+ 3.993000000000e-03 3.948607826924e-01
+ 3.994000000000e-03 7.448234920592e-01
+ 3.995000000000e-03 9.584672123084e-01
+ 3.996000000000e-03 9.168340128486e-01
+ 3.997000000000e-03 6.431054748928e-01
+ 3.998000000000e-03 2.896950669071e-01
+ 3.999000000000e-03 5.338353552207e-02
+ 4.000000000000e-03 6.575036604078e-02
+ 4.001000000000e-03 3.199096431421e-01
+ 4.002000000000e-03 6.743441642166e-01
+ 4.003000000000e-03 9.317029511588e-01
+ 4.004000000000e-03 9.486872976993e-01
+ 4.005000000000e-03 7.158402316668e-01
+ 4.006000000000e-03 3.628122061023e-01
+ 4.007000000000e-03 8.617105512270e-02
+ 4.008000000000e-03 3.995200521955e-02
+ 4.009000000000e-03 2.498900628981e-01
+ 4.010000000000e-03 5.990906296895e-01
+ 4.011000000000e-03 8.931170203564e-01
+ 4.012000000000e-03 9.682538168546e-01
+ 4.013000000000e-03 7.826644615155e-01
+ 4.014000000000e-03 4.396860691640e-01
+ 4.015000000000e-03 1.302907860646e-01
+ 4.016000000000e-03 2.675150921316e-02
+ 4.017000000000e-03 1.867194445281e-01
+ 4.018000000000e-03 5.211236166310e-01
+ 4.019000000000e-03 8.437660495256e-01
+ 4.020000000000e-03 9.749977645595e-01
+ 4.021000000000e-03 8.417482627255e-01
+ 4.022000000000e-03 5.182115571778e-01
+ 4.023000000000e-03 1.845345622164e-01
+ 4.024000000000e-03 2.651035783671e-02
+ 4.025000000000e-03 1.321276399596e-01
+ 4.026000000000e-03 4.425781585628e-01
+ 4.027000000000e-03 7.850014560533e-01
+ 4.028000000000e-03 9.687344658617e-01
+ 4.029000000000e-03 8.914736959750e-01
+ 4.030000000000e-03 5.962383434513e-01
+ 4.031000000000e-03 2.474169825619e-01
+ 4.032000000000e-03 3.923515473261e-02
+ 4.033000000000e-03 8.760958055116e-02
+ 4.034000000000e-03 3.656051290326e-01
+ 4.035000000000e-03 7.184324381379e-01
+ 4.036000000000e-03 9.496354337145e-01
+ 4.037000000000e-03 9.304790896714e-01
+ 4.038000000000e-03 6.716297576451e-01
+ 4.039000000000e-03 3.172160871321e-01
+ 4.040000000000e-03 6.457744653757e-02
+ 4.041000000000e-03 5.438434018328e-02
+ 4.042000000000e-03 2.923123425106e-01
+ 4.043000000000e-03 6.458819088195e-01
+ 4.044000000000e-03 9.182236722997e-01
+ 4.045000000000e-03 9.576963276999e-01
+ 4.046000000000e-03 7.423212959357e-01
+ 4.047000000000e-03 3.920205108228e-01
+ 4.048000000000e-03 1.018432648616e-01
+ 4.049000000000e-03 3.336175237656e-02
+ 4.050000000000e-03 2.247068344086e-01
+ 4.051000000000e-03 5.693365776826e-01
+ 4.052000000000e-03 8.753593551827e-01
+ 4.053000000000e-03 9.723800985076e-01
+ 4.054000000000e-03 8.063771549876e-01
+ 4.055000000000e-03 4.697818238447e-01
+ 4.056000000000e-03 1.500121297835e-01
+ 4.057000000000e-03 2.511749558663e-02
+ 4.058000000000e-03 1.646399008115e-01
+ 4.059000000000e-03 4.908925471874e-01
+ 4.060000000000e-03 8.222162704867e-01
+ 4.061000000000e-03 9.741283045706e-01
+ 4.062000000000e-03 8.620432416141e-01
+ 4.063000000000e-03 5.483706255249e-01
+ 4.064000000000e-03 2.077649944744e-01
+ 4.065000000000e-03 2.987732893800e-02
+ 4.066000000000e-03 1.137564029466e-01
+ 4.067000000000e-03 4.126979134087e-01
+ 4.068000000000e-03 7.602496781070e-01
+ 4.069000000000e-03 9.628930733541e-01
+ 4.070000000000e-03 9.077952065258e-01
+ 4.071000000000e-03 6.256348554033e-01
+ 4.072000000000e-03 2.735203657200e-01
+ 4.073000000000e-03 4.751091007997e-02
+ 4.074000000000e-03 7.344972462299e-02
+ 4.075000000000e-03 3.368939429899e-01
+ 4.076000000000e-03 6.911564591581e-01
+ 4.077000000000e-03 9.389820682445e-01
+ 4.078000000000e-03 9.423801868136e-01
+ 4.079000000000e-03 6.994587248360e-01
+ 4.080000000000e-03 3.454776112233e-01
+ 4.081000000000e-03 7.753536445611e-02
+ 4.082000000000e-03 4.482361608112e-02
+ 4.083000000000e-03 2.655564371141e-01
+ 4.084000000000e-03 6.168286489092e-01
+ 4.085000000000e-03 9.030500635555e-01
+ 4.086000000000e-03 9.648511141040e-01
+ 4.087000000000e-03 7.678206553407e-01
+ 4.088000000000e-03 4.216662677676e-01
+ 4.089000000000e-03 1.191285082472e-01
+ 4.090000000000e-03 2.866196910956e-02
+ 4.091000000000e-03 2.006388881676e-01
+ 4.092000000000e-03 5.393016256608e-01
+ 4.093000000000e-03 8.560810143147e-01
+ 4.094000000000e-03 9.745926488943e-01
+ 4.095000000000e-03 8.288486371073e-01
+ 4.096000000000e-03 5.000000000002e-01
+ 4.097000000000e-03 1.711513628929e-01
+ 4.098000000000e-03 2.540735110572e-02
+ 4.099000000000e-03 1.439189856851e-01
+ 4.100000000000e-03 4.606983743388e-01
+ 4.101000000000e-03 7.993611118321e-01
+ 4.102000000000e-03 9.713380308904e-01
+ 4.103000000000e-03 8.808714917532e-01
+ 4.104000000000e-03 5.783337322328e-01
+ 4.105000000000e-03 2.321793446597e-01
+ 4.106000000000e-03 3.514888589609e-02
+ 4.107000000000e-03 9.694993644430e-02
+ 4.108000000000e-03 3.831713510902e-01
+ 4.109000000000e-03 7.344435628856e-01
+ 4.110000000000e-03 9.551763839188e-01
+ 4.111000000000e-03 9.224646355441e-01
+ 4.112000000000e-03 6.545223887772e-01
+ 4.113000000000e-03 3.005412751644e-01
+ 4.114000000000e-03 5.761981318651e-02
+ 4.115000000000e-03 6.101793175532e-02
+ 4.116000000000e-03 3.088435408416e-01
+ 4.117000000000e-03 6.631060570095e-01
+ 4.118000000000e-03 9.265502753768e-01
+ 4.119000000000e-03 9.524890899202e-01
+ 4.120000000000e-03 7.264796342803e-01
+ 4.121000000000e-03 3.743651445971e-01
+ 4.122000000000e-03 9.220479347454e-02
+ 4.123000000000e-03 3.710692664585e-02
+ 4.124000000000e-03 2.397503218927e-01
+ 4.125000000000e-03 5.873020865909e-01
+ 4.126000000000e-03 8.862435970532e-01
+ 4.127000000000e-03 9.701226710621e-01
+ 4.128000000000e-03 7.922350055259e-01
+ 4.129000000000e-03 4.516293744755e-01
+ 4.130000000000e-03 1.379567583862e-01
+ 4.131000000000e-03 2.587169542936e-02
+ 4.132000000000e-03 1.777837295130e-01
+ 4.133000000000e-03 5.091074528120e-01
+ 4.134000000000e-03 8.353600991883e-01
+ 4.135000000000e-03 9.748825044134e-01
+ 4.136000000000e-03 8.499878702169e-01
+ 4.137000000000e-03 5.302181761557e-01
+ 4.138000000000e-03 1.936228450127e-01
+ 4.139000000000e-03 2.761990149242e-02
+ 4.140000000000e-03 1.246406448171e-01
+ 4.141000000000e-03 4.306634223170e-01
+ 4.142000000000e-03 7.752931655911e-01
+ 4.143000000000e-03 9.666382476234e-01
+ 4.144000000000e-03 8.981567351386e-01
+ 4.145000000000e-03 6.079794891775e-01
+ 4.146000000000e-03 2.576787040646e-01
+ 4.147000000000e-03 4.230367230023e-02
+ 4.148000000000e-03 8.177632770014e-02
+ 4.149000000000e-03 3.541180911801e-01
+ 4.150000000000e-03 7.076876574888e-01
+ 4.151000000000e-03 9.456156598166e-01
+ 4.152000000000e-03 9.354225534627e-01
+ 4.153000000000e-03 6.827839128682e-01
+ 4.154000000000e-03 3.283702423552e-01
+ 4.155000000000e-03 6.952091032871e-02
+ 4.156000000000e-03 5.036456628542e-02
+ 4.157000000000e-03 2.815675618618e-01
+ 4.158000000000e-03 6.343948709670e-01
+ 4.159000000000e-03 9.123904194487e-01
+ 4.160000000000e-03 9.607648452675e-01
+ 4.161000000000e-03 7.525830174386e-01
+ 4.162000000000e-03 4.037616565490e-01
+ 4.163000000000e-03 1.085263040252e-01
+ 4.164000000000e-03 3.126553413824e-02
+ 4.165000000000e-03 2.149985439464e-01
+ 4.166000000000e-03 5.574218414366e-01
+ 4.167000000000e-03 8.678723600402e-01
+ 4.168000000000e-03 9.734896421633e-01
+ 4.169000000000e-03 8.154654377839e-01
+ 4.170000000000e-03 4.817884428226e-01
+ 4.171000000000e-03 1.582517372748e-01
+ 4.172000000000e-03 2.500223544045e-02
+ 4.173000000000e-03 1.562339504742e-01
+ 4.174000000000e-03 4.788763833686e-01
+ 4.175000000000e-03 8.132805554715e-01
+ 4.176000000000e-03 9.732484907868e-01
+ 4.177000000000e-03 8.697092139356e-01
+ 4.178000000000e-03 5.603139308363e-01
+ 4.179000000000e-03 2.173355384849e-01
+ 4.180000000000e-03 3.174618314547e-02
+ 4.181000000000e-03 1.068829796434e-01
+ 4.182000000000e-03 4.009093703102e-01
+ 4.183000000000e-03 7.501099371016e-01
+ 4.184000000000e-03 9.600479947804e-01
+ 4.185000000000e-03 9.138289448776e-01
+ 4.186000000000e-03 6.371877938981e-01
+ 4.187000000000e-03 2.841597683335e-01
+ 4.188000000000e-03 5.131270230087e-02
+ 4.189000000000e-03 6.829704884091e-02
+ 4.190000000000e-03 3.256558357831e-01
+ 4.191000000000e-03 6.800903568575e-01
+ 4.192000000000e-03 9.342496339591e-01
+ 4.193000000000e-03 9.466164644781e-01
+ 4.194000000000e-03 7.103049330934e-01
+ 4.195000000000e-03 3.568945251075e-01
+ 4.196000000000e-03 8.316598715161e-02
+ 4.197000000000e-03 4.153278769150e-02
+ 4.198000000000e-03 2.551765079404e-01
+ 4.199000000000e-03 6.051392173070e-01
+ 4.200000000000e-03 8.965598656184e-01
+ 4.201000000000e-03 9.671739256774e-01
+ 4.202000000000e-03 7.776631229028e-01
+ 4.203000000000e-03 4.335480543738e-01
+ 4.204000000000e-03 1.264337735407e-01
+ 4.205000000000e-03 2.732310351696e-02
+ 4.206000000000e-03 1.914013789892e-01
+ 4.207000000000e-03 5.273089658783e-01
+ 4.208000000000e-03 8.480107790442e-01
+ 4.209000000000e-03 9.749383869563e-01
+ 4.210000000000e-03 8.374178397572e-01
+ 4.211000000000e-03 5.120212907948e-01
+ 4.212000000000e-03 1.799312248203e-01
+ 4.213000000000e-03 2.605711154519e-02
+ 4.214000000000e-03 1.360768546567e-01
+ 4.215000000000e-03 4.487308910394e-01
+ 4.216000000000e-03 7.899318329811e-01
+ 4.217000000000e-03 9.696972278171e-01
+ 4.218000000000e-03 8.879327721120e-01
+ 4.219000000000e-03 5.901653385265e-01
+ 4.220000000000e-03 2.421933771895e-01
+ 4.221000000000e-03 3.776947945408e-02
+ 4.222000000000e-03 9.071793095692e-02
+ 4.223000000000e-03 3.715567595089e-01
+ 4.224000000000e-03 7.239134499921e-01
+ 4.225000000000e-03 9.515939711425e-01
+ 4.226000000000e-03 9.278246288837e-01
+ 4.227000000000e-03 6.658403161645e-01
+ 4.228000000000e-03 3.115152559771e-01
+ 4.229000000000e-03 6.213947803872e-02
+ 4.230000000000e-03 5.656670783494e-02
+ 4.231000000000e-03 2.978998926948e-01
+ 4.232000000000e-03 6.517634646373e-01
+ 4.233000000000e-03 9.211243529923e-01
+ 4.234000000000e-03 9.560010192254e-01
+ 4.235000000000e-03 7.369739548385e-01
+ 4.236000000000e-03 3.859985643370e-01
+ 4.237000000000e-03 9.849976399780e-02
+ 4.238000000000e-03 3.455837574269e-02
+ 4.239000000000e-03 2.297772959132e-01
+ 4.240000000000e-03 5.754576180834e-01
+ 4.241000000000e-03 8.791227474637e-01
+ 4.242000000000e-03 9.716903663440e-01
+ 4.243000000000e-03 8.016183448224e-01
+ 4.244000000000e-03 4.636036658391e-01
+ 4.245000000000e-03 1.458546543319e-01
+ 4.246000000000e-03 2.529560656569e-02
+ 4.247000000000e-03 1.690544251050e-01
+ 4.248000000000e-03 4.970854547915e-01
+ 4.249000000000e-03 8.267393183541e-01
+ 4.250000000000e-03 9.744630362093e-01
+ 4.251000000000e-03 8.580032767129e-01
+ 4.252000000000e-03 5.422054374769e-01
+ 4.253000000000e-03 2.029073919343e-01
+ 4.254000000000e-03 2.903205017362e-02
+ 4.255000000000e-03 1.173941035542e-01
+ 4.256000000000e-03 4.187931028389e-01
+ 4.257000000000e-03 7.654085232976e-01
+ 4.258000000000e-03 9.642431025689e-01
+ 4.259000000000e-03 9.045847165017e-01
+ 4.260000000000e-03 6.196514636235e-01
+ 4.261000000000e-03 2.680956557347e-01
+ 4.262000000000e-03 4.566538852138e-02
+ 4.263000000000e-03 7.621098745895e-02
+ 4.264000000000e-03 3.427245047638e-01
+ 4.265000000000e-03 6.968098328585e-01
+ 4.266000000000e-03 9.413104260981e-01
+ 4.267000000000e-03 9.400870871012e-01
+ 4.268000000000e-03 6.938209773610e-01
+ 4.269000000000e-03 3.396343429957e-01
+ 4.270000000000e-03 7.474013750685e-02
+ 4.271000000000e-03 4.663282726079e-02
+ 4.272000000000e-03 2.709627082623e-01
+ 4.273000000000e-03 6.228217402338e-01
+ 4.274000000000e-03 9.062929907491e-01
+ 4.275000000000e-03 9.635381984997e-01
+ 4.276000000000e-03 7.626829351509e-01
+ 4.277000000000e-03 4.155644522187e-01
+ 4.278000000000e-03 1.154601198582e-01
+ 4.279000000000e-03 2.946958554596e-02
+ 4.280000000000e-03 2.054728244124e-01
+ 4.281000000000e-03 5.454703209621e-01
+ 4.282000000000e-03 8.601497071611e-01
+ 4.283000000000e-03 9.742958700238e-01
+ 4.284000000000e-03 8.243516345332e-01
+ 4.285000000000e-03 4.938067280604e-01
+ 4.286000000000e-03 1.667102674985e-01
+ 4.287000000000e-03 2.519125718742e-02
+ 4.288000000000e-03 1.480482154563e-01
+ 4.289000000000e-03 4.668737512642e-01
+ 4.290000000000e-03 8.041441540372e-01
+ 4.291000000000e-03 9.720655156884e-01
+ 4.292000000000e-03 8.771383518384e-01
+ 4.293000000000e-03 5.722185992561e-01
+ 4.294000000000e-03 2.270871563524e-01
+ 4.295000000000e-03 3.391499909685e-02
+ 4.296000000000e-03 1.002613857173e-01
+ 4.297000000000e-03 3.891843043194e-01
+ 4.298000000000e-03 7.398099765521e-01
+ 4.299000000000e-03 9.569082110831e-01
+ 4.300000000000e-03 9.195975858663e-01
+ 4.301000000000e-03 6.486528503756e-01
+ 4.302000000000e-03 2.949374374384e-01
+ 4.303000000000e-03 5.540192202263e-02
+ 4.304000000000e-03 6.342092044708e-02
+ 4.305000000000e-03 3.145294128327e-01
+ 4.306000000000e-03 6.689088893096e-01
+ 4.307000000000e-03 9.292390208893e-01
+ 4.308000000000e-03 9.505666412100e-01
+ 4.309000000000e-03 7.210164207521e-01
+ 4.310000000000e-03 3.684031118548e-01
+ 4.311000000000e-03 8.906363224609e-02
+ 4.312000000000e-03 3.853565178147e-02
+ 4.313000000000e-03 2.449534118327e-01
+ 4.314000000000e-03 5.933824338932e-01
+ 4.315000000000e-03 8.898156328297e-01
+ 4.316000000000e-03 9.691974672812e-01
+ 4.317000000000e-03 7.873277204477e-01
+ 4.318000000000e-03 4.454724098622e-01
+ 4.319000000000e-03 1.339783440414e-01
+ 4.320000000000e-03 2.628703307761e-02
+ 4.321000000000e-03 1.823615569995e-01
+ 4.322000000000e-03 5.152988120686e-01
+ 4.323000000000e-03 8.397176092956e-01
+ 4.324000000000e-03 9.749798811622e-01
+ 4.325000000000e-03 8.457708937287e-01
+ 4.326000000000e-03 5.240348807927e-01
+ 4.327000000000e-03 1.889161216764e-01
+ 4.328000000000e-03 2.701047812790e-02
+ 4.329000000000e-03 1.284678515120e-01
+ 4.330000000000e-03 4.367962505501e-01
+ 4.331000000000e-03 7.803168248201e-01
+ 4.332000000000e-03 9.677555383559e-01
+ 4.333000000000e-03 8.947455441046e-01
+ 4.334000000000e-03 6.019391852221e-01
+ 4.335000000000e-03 2.523725597329e-01
+ 4.336000000000e-03 4.068617625378e-02
+ 4.337000000000e-03 8.474811011975e-02
+ 4.338000000000e-03 3.600244482141e-01
+ 4.339000000000e-03 7.132398989324e-01
+ 4.340000000000e-03 9.477222688606e-01
+ 4.341000000000e-03 9.329105592746e-01
+ 4.342000000000e-03 6.770520068299e-01
+ 4.343000000000e-03 3.226099794527e-01
+ 4.344000000000e-03 6.693963479750e-02
+ 4.345000000000e-03 5.239954571806e-02
+ 4.346000000000e-03 2.870857091643e-01
+ 4.347000000000e-03 6.403236531251e-01
+ 4.348000000000e-03 9.154286598319e-01
+ 4.349000000000e-03 9.592208358857e-01
+ 4.350000000000e-03 7.473164707169e-01
+ 4.351000000000e-03 3.977050129949e-01
+ 4.352000000000e-03 1.050519341563e-01
+ 4.353000000000e-03 3.230798510294e-02
+ 4.354000000000e-03 2.199773736454e-01
+ 4.355000000000e-03 5.635648116917e-01
+ 4.356000000000e-03 8.717590331789e-01
+ 4.357000000000e-03 9.729558984405e-01
+ 4.358000000000e-03 8.108084684702e-01
+ 4.359000000000e-03 4.756012725658e-01
+ 4.360000000000e-03 1.539794145372e-01
+ 4.361000000000e-03 2.502361166266e-02
+ 4.362000000000e-03 1.605371232649e-01
+ 4.363000000000e-03 4.850653238180e-01
+ 4.364000000000e-03 8.179092294645e-01
+ 4.365000000000e-03 9.737396286571e-01
+ 4.366000000000e-03 8.657893475719e-01
+ 4.367000000000e-03 5.541656621434e-01
+ 4.368000000000e-03 2.123822553332e-01
+ 4.369000000000e-03 3.074589926288e-02
+ 4.370000000000e-03 1.103926582793e-01
+ 4.371000000000e-03 4.069748042123e-01
+ 4.372000000000e-03 7.553538612403e-01
+ 4.373000000000e-03 9.615505650199e-01
+ 4.374000000000e-03 9.107535223219e-01
+ 4.375000000000e-03 6.312467897640e-01
+ 4.376000000000e-03 2.786611645105e-01
+ 4.377000000000e-03 4.931814989279e-02
+ 4.378000000000e-03 7.091712496503e-02
+ 4.379000000000e-03 3.314316684754e-01
+ 4.380000000000e-03 6.858059325436e-01
+ 4.381000000000e-03 9.367224904767e-01
+ 4.382000000000e-03 9.444697025036e-01
+ 4.383000000000e-03 7.047338808193e-01
+ 4.384000000000e-03 3.510011733108e-01
+ 4.385000000000e-03 8.023178465325e-02
+ 4.386000000000e-03 4.319151364865e-02
+ 4.387000000000e-03 2.605045751442e-01
+ 4.388000000000e-03 6.111699303269e-01
+ 4.389000000000e-03 8.999352921922e-01
+ 4.390000000000e-03 9.660146107965e-01
+ 4.391000000000e-03 7.726145791008e-01
+ 4.392000000000e-03 4.274213370024e-01
+ 4.393000000000e-03 1.226402705825e-01
+ 4.394000000000e-03 2.797505707811e-02
+ 4.395000000000e-03 1.961357779481e-01
+ 4.396000000000e-03 5.334896723599e-01
+ 4.397000000000e-03 8.521963436494e-01
+ 4.398000000000e-03 9.747982656222e-01
+ 4.399000000000e-03 8.330300527688e-01
+ 4.400000000000e-03 5.058289806862e-01
+ 4.401000000000e-03 1.753823019497e-01
+ 4.402000000000e-03 2.568443974088e-02
+ 4.403000000000e-03 1.400879395104e-01
+ 4.404000000000e-03 4.548923397181e-01
+ 4.405000000000e-03 7.948129189305e-01
+ 4.406000000000e-03 9.705801370853e-01
+ 4.407000000000e-03 8.843258962429e-01
+ 4.408000000000e-03 5.840770046961e-01
+ 4.409000000000e-03 2.370136012257e-01
+ 4.410000000000e-03 3.638238745649e-02
+ 4.411000000000e-03 9.389586293823e-02
+ 4.412000000000e-03 3.775302264728e-01
+ 4.413000000000e-03 7.293563945772e-01
+ 4.414000000000e-03 9.534757335970e-01
+ 4.415000000000e-03 9.250974341211e-01
+ 4.416000000000e-03 6.600226803615e-01
+ 4.417000000000e-03 3.058464688976e-01
+ 4.418000000000e-03 5.977594970541e-02
+ 4.419000000000e-03 5.882446307241e-02
+ 4.420000000000e-03 3.035218016865e-01
+ 4.421000000000e-03 6.576192193226e-01
+ 4.422000000000e-03 9.239534388162e-01
+ 4.423000000000e-03 9.542281865404e-01
+ 4.424000000000e-03 7.315863260706e-01
+ 4.425000000000e-03 3.799959991044e-01
+ 4.426000000000e-03 9.522452172882e-02
+ 4.427000000000e-03 3.583412830581e-02
+ 4.428000000000e-03 2.348936976699e-01
+ 4.429000000000e-03 5.815658300212e-01
+ 4.430000000000e-03 8.828216855212e-01
+ 4.431000000000e-03 9.709204426419e-01
+ 4.432000000000e-03 7.968082568678e-01
+ 4.433000000000e-03 4.574316955327e-01
+ 4.434000000000e-03 1.417573867246e-01
+ 4.435000000000e-03 2.555442149456e-02
+ 4.436000000000e-03 1.735252130762e-01
+ 4.437000000000e-03 5.032788578940e-01
+ 4.438000000000e-03 8.312068176446e-01
+ 4.439000000000e-03 9.747171049310e-01
+ 4.440000000000e-03 8.539024480849e-01
+ 4.441000000000e-03 5.360330741310e-01
+ 4.442000000000e-03 1.981002977682e-01
+ 4.443000000000e-03 2.826684013053e-02
+ 4.444000000000e-03 1.210968505518e-01
+ 4.445000000000e-03 4.249020981601e-01
+ 4.446000000000e-03 7.705222466895e-01
+ 4.447000000000e-03 9.655142063460e-01
+ 4.448000000000e-03 9.013054434937e-01
+ 4.449000000000e-03 6.136477300353e-01
+ 4.450000000000e-03 2.627103715413e-01
+ 4.451000000000e-03 4.389710786938e-02
+ 4.452000000000e-03 7.904429817928e-02
+ 4.453000000000e-03 3.485818047643e-01
+ 4.454000000000e-03 7.024297471450e-01
+ 4.455000000000e-03 9.435637572720e-01
+ 4.456000000000e-03 9.377191686876e-01
+ 4.457000000000e-03 6.881502786036e-01
+ 4.458000000000e-03 3.338183383498e-01
+ 4.459000000000e-03 7.201720849928e-02
+ 4.460000000000e-03 4.851911487390e-02
+ 4.461000000000e-03 2.764079177776e-01
+ 4.462000000000e-03 6.287939507751e-01
+ 4.463000000000e-03 9.094668445372e-01
+ 4.464000000000e-03 9.621464772977e-01
+ 4.465000000000e-03 7.575005565361e-01
+ 4.466000000000e-03 4.094769914608e-01
+ 4.467000000000e-03 1.118571066535e-01
+ 4.468000000000e-03 3.035719631882e-02
+ 4.469000000000e-03 2.103568328845e-01
+ 4.470000000000e-03 5.516312859060e-01
+ 4.471000000000e-03 8.641571713685e-01
+ 4.472000000000e-03 9.739184566560e-01
+ 4.473000000000e-03 8.197994893094e-01
+ 4.474000000000e-03 4.876145090315e-01
+ 4.475000000000e-03 1.623258343097e-01
+ 4.476000000000e-03 2.505588495925e-02
+ 4.477000000000e-03 1.522372801471e-01
+ 4.478000000000e-03 4.730547599456e-01
+ 4.479000000000e-03 8.088754890434e-01
+ 4.480000000000e-03 9.727127451693e-01
+ 4.481000000000e-03 8.733410950648e-01
+ 4.482000000000e-03 5.660911884780e-01
+ 4.483000000000e-03 2.220413656449e-01
+ 4.484000000000e-03 3.276035087446e-02
+ 4.485000000000e-03 1.036407940939e-01
+ 4.486000000000e-03 3.952160971979e-01
+ 4.487000000000e-03 7.451356203996e-01
+ 4.488000000000e-03 9.585623598063e-01
+ 4.489000000000e-03 9.166592008840e-01
+ 4.490000000000e-03 6.427580396732e-01
+ 4.491000000000e-03 2.893684621634e-01
+ 4.492000000000e-03 5.325961646829e-02
+ 4.493000000000e-03 6.589813144782e-02
+ 4.494000000000e-03 3.202468164656e-01
+ 4.495000000000e-03 6.746830056030e-01
+ 4.496000000000e-03 9.318547919680e-01
+ 4.497000000000e-03 9.485675921817e-01
+ 4.498000000000e-03 7.155156324754e-01
+ 4.499000000000e-03 3.624634517489e-01
+ 4.500000000000e-03 8.599233383861e-02
+ 4.501000000000e-03 4.004282994204e-02
+ 4.502000000000e-03 2.501998619511e-01
+ 4.503000000000e-03 5.994469053548e-01
+ 4.504000000000e-03 8.933213964974e-01
+ 4.505000000000e-03 9.681924957768e-01
+ 4.506000000000e-03 7.823715871129e-01
+ 4.507000000000e-03 4.393247154219e-01
+ 4.508000000000e-03 1.300621566190e-01
+ 4.509000000000e-03 2.678290612440e-02
+ 4.510000000000e-03 1.869933858335e-01
+ 4.511000000000e-03 5.214875703916e-01
+ 4.512000000000e-03 8.440173644017e-01
+ 4.513000000000e-03 9.749965071258e-01
+ 4.514000000000e-03 8.414951331273e-01
+ 4.515000000000e-03 5.178474992870e-01
+ 4.516000000000e-03 1.842622853535e-01
+ 4.517000000000e-03 2.648146716980e-02
+ 4.518000000000e-03 1.323582219615e-01
+ 4.519000000000e-03 4.429398239800e-01
+ 4.520000000000e-03 7.852928277072e-01
+ 4.521000000000e-03 9.687933065055e-01
+ 4.522000000000e-03 8.912672428331e-01
+ 4.523000000000e-03 5.958815507029e-01
+ 4.524000000000e-03 2.471085142587e-01
+ 4.525000000000e-03 3.914676762402e-02
+ 4.526000000000e-03 8.779048903730e-02
+ 4.527000000000e-03 3.659546023311e-01
+ 4.528000000000e-03 7.187558877049e-01
+ 4.529000000000e-03 9.497527611550e-01
+ 4.530000000000e-03 9.303249664585e-01
+ 4.531000000000e-03 6.712900003826e-01
+ 4.532000000000e-03 3.168798744245e-01
+ 4.533000000000e-03 6.443198336268e-02
+ 4.534000000000e-03 5.451062119095e-02
+ 4.535000000000e-03 2.926400537816e-01
+ 4.536000000000e-03 6.462285790196e-01
+ 4.537000000000e-03 9.183962736650e-01
+ 4.538000000000e-03 9.575987548961e-01
+ 4.539000000000e-03 7.420078780055e-01
+ 4.540000000000e-03 3.916657604940e-01
+ 4.541000000000e-03 1.016447089556e-01
+ 4.542000000000e-03 3.342994785097e-02
+ 4.543000000000e-03 2.250038096700e-01
+ 4.544000000000e-03 5.696969753660e-01
+ 4.545000000000e-03 8.755825039906e-01
+ 4.546000000000e-03 9.723417480274e-01
+ 4.547000000000e-03 8.060986589652e-01
+ 4.548000000000e-03 4.694182503084e-01
+ 4.549000000000e-03 1.497659183626e-01
+ 4.550000000000e-03 2.512573807623e-02
+ 4.551000000000e-03 1.648980077503e-01
+ 4.552000000000e-03 4.912568032944e-01
+ 4.553000000000e-03 8.224838560738e-01
+ 4.554000000000e-03 9.741502265962e-01
+ 4.555000000000e-03 8.618072937806e-01
+ 4.556000000000e-03 5.480081848087e-01
+ 4.557000000000e-03 2.074778697447e-01
+ 4.558000000000e-03 2.982539273209e-02
+ 4.559000000000e-03 1.139685736130e-01
+ 4.560000000000e-03 4.130560532211e-01
+ 4.561000000000e-03 7.605543729617e-01
+ 4.562000000000e-03 9.629746675770e-01
+ 4.563000000000e-03 9.076082680306e-01
+ 4.564000000000e-03 6.252834725133e-01
+ 4.565000000000e-03 2.732001902491e-01
+ 4.566000000000e-03 4.740021738953e-02
+ 4.567000000000e-03 7.361014897690e-02
+ 4.568000000000e-03 3.372361592767e-01
+ 4.569000000000e-03 6.914899195756e-01
+ 4.570000000000e-03 9.391211003044e-01
+ 4.571000000000e-03 9.422473767445e-01
+ 4.572000000000e-03 6.991280219727e-01
+ 4.573000000000e-03 3.451331526335e-01
+ 4.574000000000e-03 7.736894646813e-02
+ 4.575000000000e-03 4.492790109290e-02
+ 4.576000000000e-03 2.658733586908e-01
+ 4.577000000000e-03 6.171817434742e-01
+ 4.578000000000e-03 9.032427262254e-01
+ 4.579000000000e-03 9.647760693058e-01
+ 4.580000000000e-03 7.675196884068e-01
+ 4.581000000000e-03 4.213069586463e-01
+ 4.582000000000e-03 1.189109221194e-01
+ 4.583000000000e-03 2.870725905879e-02
+ 4.584000000000e-03 2.009218365152e-01
+ 4.585000000000e-03 5.396646853004e-01
+ 4.586000000000e-03 8.563220317579e-01
+ 4.587000000000e-03 9.745774243792e-01
+ 4.588000000000e-03 8.285856477231e-01
+ 4.589000000000e-03 4.996356795988e-01
+ 4.590000000000e-03 1.708885669620e-01
+ 4.591000000000e-03 2.539240578130e-02
+ 4.592000000000e-03 1.441602126012e-01
+ 4.593000000000e-03 4.610614570988e-01
+ 4.594000000000e-03 7.996438840733e-01
+ 4.595000000000e-03 9.713830435637e-01
+ 4.596000000000e-03 8.806536815688e-01
+ 4.597000000000e-03 5.779743770302e-01
+ 4.598000000000e-03 2.318785352780e-01
+ 4.599000000000e-03 3.507411455784e-02
+ 4.600000000000e-03 9.714283621839e-02
+ 4.601000000000e-03 3.835245143828e-01
+ 4.602000000000e-03 7.347603465450e-01
+ 4.603000000000e-03 9.552804011619e-01
+ 4.604000000000e-03 9.222979690311e-01
+ 4.605000000000e-03 6.541778392863e-01
+ 4.606000000000e-03 3.002106896372e-01
+ 4.607000000000e-03 5.748726335822e-02
+ 4.608000000000e-03 6.115722205707e-02
+ 4.609000000000e-03 3.091771137113e-01
+ 4.610000000000e-03 6.634481773448e-01
+ 4.611000000000e-03 9.267104488020e-01
+ 4.612000000000e-03 9.523781310420e-01
+ 4.613000000000e-03 7.261593255771e-01
+ 4.614000000000e-03 3.740138356144e-01
+ 4.615000000000e-03 9.201809487481e-02
+ 4.616000000000e-03 3.718879317679e-02
+ 4.617000000000e-03 2.400551698454e-01
+ 4.618000000000e-03 5.876601750455e-01
+ 4.619000000000e-03 8.864555405026e-01
+ 4.620000000000e-03 9.700704582950e-01
+ 4.621000000000e-03 7.919477088818e-01
+ 4.622000000000e-03 4.512669622147e-01
+ 4.623000000000e-03 1.377210235335e-01
+ 4.624000000000e-03 2.589389637241e-02
+ 4.625000000000e-03 1.780515046519e-01
+ 4.626000000000e-03 5.094717035618e-01
+ 4.627000000000e-03 8.356180088436e-01
+ 4.628000000000e-03 9.748904675418e-01
+ 4.629000000000e-03 8.497414529075e-01
+ 4.630000000000e-03 5.298545848432e-01
+ 4.631000000000e-03 1.933445292242e-01
+ 4.632000000000e-03 2.758182890126e-02
+ 4.633000000000e-03 1.248640144394e-01
+ 4.634000000000e-03 4.310238607898e-01
+ 4.635000000000e-03 7.755899789043e-01
+ 4.636000000000e-03 9.667061685865e-01
+ 4.637000000000e-03 8.979579450074e-01
+ 4.638000000000e-03 6.076246753270e-01
+ 4.639000000000e-03 2.573654286854e-01
+ 4.640000000000e-03 4.220636874721e-02
+ 4.641000000000e-03 8.194917509576e-02
+ 4.642000000000e-03 3.544648471985e-01
+ 4.643000000000e-03 7.080152465820e-01
+ 4.644000000000e-03 9.457416786799e-01
+ 4.645000000000e-03 9.352768341397e-01
+ 4.646000000000e-03 6.824475926332e-01
+ 4.647000000000e-03 3.280305860579e-01
+ 4.648000000000e-03 6.936704035543e-02
+ 4.649000000000e-03 5.048215823478e-02
+ 4.650000000000e-03 2.818911399268e-01
+ 4.651000000000e-03 6.347442652042e-01
+ 4.652000000000e-03 9.125710853362e-01
+ 4.653000000000e-03 9.606761871027e-01
+ 4.654000000000e-03 7.522744005469e-01
+ 4.655000000000e-03 4.034049204155e-01
+ 4.656000000000e-03 1.083200811773e-01
+ 4.657000000000e-03 3.132465052637e-02
+ 4.658000000000e-03 2.152900832596e-01
+ 4.659000000000e-03 5.577834730744e-01
+ 4.660000000000e-03 8.681027256325e-01
+ 4.661000000000e-03 9.734604729547e-01
+ 4.662000000000e-03 8.151929753410e-01
+ 4.663000000000e-03 4.814243956456e-01
+ 4.664000000000e-03 1.579988087185e-01
+ 4.665000000000e-03 2.500125743569e-02
+ 4.666000000000e-03 1.564854675792e-01
+ 4.667000000000e-03 4.792403495562e-01
+ 4.668000000000e-03 8.135543124818e-01
+ 4.669000000000e-03 9.732796092981e-01
+ 4.670000000000e-03 8.694803669997e-01
+ 4.671000000000e-03 5.599525416128e-01
+ 4.672000000000e-03 2.170428303662e-01
+ 4.673000000000e-03 3.168513752922e-02
+ 4.674000000000e-03 1.070875870449e-01
+ 4.675000000000e-03 4.012657042677e-01
+ 4.676000000000e-03 7.504195890211e-01
+ 4.677000000000e-03 9.601385488684e-01
+ 4.678000000000e-03 9.136499801484e-01
+ 4.679000000000e-03 6.368389588404e-01
+ 4.680000000000e-03 2.838352961152e-01
+ 4.681000000000e-03 5.119326073457e-02
+ 4.682000000000e-03 6.844914360957e-02
+ 4.683000000000e-03 3.259947797313e-01
+ 4.684000000000e-03 6.804274242387e-01
+ 4.685000000000e-03 9.343971439083e-01
+ 4.686000000000e-03 9.464922826912e-01
+ 4.687000000000e-03 7.099782046328e-01
+ 4.688000000000e-03 3.565471740737e-01
+ 4.689000000000e-03 8.299142039980e-02
+ 4.690000000000e-03 4.162820489383e-02
+ 4.691000000000e-03 2.554887803046e-01
+ 4.692000000000e-03 6.054944699621e-01
+ 4.693000000000e-03 8.967602920451e-01
+ 4.694000000000e-03 9.671079274028e-01
+ 4.695000000000e-03 7.773674481084e-01
+ 4.696000000000e-03 4.331873363173e-01
+ 4.697000000000e-03 1.262088619051e-01
+ 4.698000000000e-03 2.735923026687e-02
+ 4.699000000000e-03 1.916784285630e-01
+ 4.700000000000e-03 5.276726756377e-01
+ 4.701000000000e-03 8.482586335099e-01
+ 4.702000000000e-03 9.749323794778e-01
+ 4.703000000000e-03 8.371613153296e-01
+ 4.704000000000e-03 5.116570835487e-01
+ 4.705000000000e-03 1.796621272376e-01
+ 4.706000000000e-03 2.603295855473e-02
+ 4.707000000000e-03 1.363110947684e-01
+ 4.708000000000e-03 4.490930981452e-01
+ 4.709000000000e-03 7.902203282875e-01
+ 4.710000000000e-03 9.697513756423e-01
+ 4.711000000000e-03 8.877224226661e-01
+ 4.712000000000e-03 5.898076154713e-01
+ 4.713000000000e-03 2.418874625758e-01
+ 4.714000000000e-03 3.768570812411e-02
+ 4.715000000000e-03 9.090294722121e-02
+ 4.716000000000e-03 3.719075453527e-01
+ 4.717000000000e-03 7.242346860399e-01
+ 4.718000000000e-03 9.517067914979e-01
+ 4.719000000000e-03 9.276662145882e-01
+ 4.720000000000e-03 6.654988731189e-01
+ 4.721000000000e-03 3.111809014387e-01
+ 4.722000000000e-03 6.199838234702e-02
+ 4.723000000000e-03 5.669743380243e-02
+ 4.724000000000e-03 2.982296514254e-01
+ 4.725000000000e-03 6.521086447611e-01
+ 4.726000000000e-03 9.212927564273e-01
+ 4.727000000000e-03 9.558988780665e-01
+ 4.728000000000e-03 7.366581418124e-01
+ 4.729000000000e-03 3.856449257733e-01
+ 4.730000000000e-03 9.830520768112e-02
+ 4.731000000000e-03 3.463123163881e-02
+ 4.732000000000e-03 2.300769974815e-01
+ 4.733000000000e-03 5.758172899373e-01
+ 4.734000000000e-03 8.793421224513e-01
+ 4.735000000000e-03 9.716472953352e-01
+ 4.736000000000e-03 8.013368099779e-01
+ 4.737000000000e-03 4.632404272195e-01
+ 4.738000000000e-03 1.456119650829e-01
+ 4.739000000000e-03 2.530859731875e-02
+ 4.740000000000e-03 1.693158625413e-01
+ 4.741000000000e-03 4.974497691918e-01
+ 4.742000000000e-03 8.270036575722e-01
+ 4.743000000000e-03 9.744802147987e-01
+ 4.744000000000e-03 8.577637295458e-01
+ 4.745000000000e-03 5.418425456574e-01
+ 4.746000000000e-03 2.026232155081e-01
+ 4.747000000000e-03 2.898482004739e-02
+ 4.748000000000e-03 1.176101177069e-01
+ 4.749000000000e-03 4.191520834708e-01
+ 4.750000000000e-03 7.657105881329e-01
+ 4.751000000000e-03 9.643200603415e-01
+ 4.752000000000e-03 9.043937167251e-01
+ 4.753000000000e-03 6.192988559634e-01
+ 4.754000000000e-03 2.677777739633e-01
+ 4.755000000000e-03 4.555923085646e-02
+ 4.756000000000e-03 7.637566303852e-02
+ 4.757000000000e-03 3.430683213718e-01
+ 4.758000000000e-03 6.971413516261e-01
+ 4.759000000000e-03 9.414450556572e-01
+ 4.760000000000e-03 9.399498650158e-01
+ 4.761000000000e-03 6.934883095995e-01
+ 4.762000000000e-03 3.392914606917e-01
+ 4.763000000000e-03 7.457795930390e-02
+ 4.764000000000e-03 4.674165482313e-02
+ 4.765000000000e-03 2.712819458390e-01
+ 4.766000000000e-03 6.231736346877e-01
+ 4.767000000000e-03 9.064816054248e-01
+ 4.768000000000e-03 9.634585117683e-01
+ 4.769000000000e-03 7.623793169970e-01
+ 4.770000000000e-03 4.152059588042e-01
+ 4.771000000000e-03 1.152463621739e-01
+ 4.772000000000e-03 2.951958497818e-02
+ 4.773000000000e-03 2.057587410180e-01
+ 4.774000000000e-03 5.458329548935e-01
+ 4.775000000000e-03 8.603871419660e-01
+ 4.776000000000e-03 9.742759007723e-01
+ 4.777000000000e-03 8.240853802079e-01
+ 4.778000000000e-03 4.934424404493e-01
+ 4.779000000000e-03 1.664507838317e-01
+ 4.780000000000e-03 2.518105931480e-02
+ 4.781000000000e-03 1.482929816062e-01
+ 4.782000000000e-03 4.672371943764e-01
+ 4.783000000000e-03 8.044239071030e-01
+ 4.784000000000e-03 9.721058107511e-01
+ 4.785000000000e-03 8.769167523983e-01
+ 4.786000000000e-03 5.718584930301e-01
+ 4.787000000000e-03 2.267890523531e-01
+ 4.788000000000e-03 3.384488317601e-02
+ 4.789000000000e-03 1.004582987831e-01
+ 4.790000000000e-03 3.895386041563e-01
+ 4.791000000000e-03 7.401243871751e-01
+ 4.792000000000e-03 9.570076670277e-01
+ 4.793000000000e-03 9.194267095474e-01
+ 4.794000000000e-03 6.483067866132e-01
+ 4.795000000000e-03 2.946088763286e-01
+ 4.796000000000e-03 5.527380809416e-02
+ 4.797000000000e-03 6.356458819947e-02
+ 4.798000000000e-03 3.148648673167e-01
+ 4.799000000000e-03 6.692493477300e-01
+ 4.800000000000e-03 9.293949142335e-01
+ 4.801000000000e-03 9.504511672560e-01
+ 4.802000000000e-03 7.206938759956e-01
+ 4.803000000000e-03 3.680530908881e-01
+ 4.804000000000e-03 8.888102855708e-02
+ 4.805000000000e-03 3.862214005050e-02
+ 4.806000000000e-03 2.452608349433e-01
+ 4.807000000000e-03 5.937396170642e-01
+ 4.808000000000e-03 8.900236946206e-01
+ 4.809000000000e-03 9.691405578084e-01
+ 4.810000000000e-03 7.870375272004e-01
+ 4.811000000000e-03 4.451105139444e-01
+ 4.812000000000e-03 1.337462509758e-01
+ 4.813000000000e-03 2.631397348550e-02
+ 4.814000000000e-03 1.826325303222e-01
+ 4.815000000000e-03 5.156629389561e-01
+ 4.816000000000e-03 8.399721420097e-01
+ 4.817000000000e-03 9.749830945686e-01
+ 4.818000000000e-03 8.455209985864e-01
+ 4.819000000000e-03 5.236710200119e-01
+ 4.820000000000e-03 1.886408948255e-01
+ 4.821000000000e-03 2.697713294373e-02
+ 4.822000000000e-03 1.286949547661e-01
+ 4.823000000000e-03 4.371573499737e-01
+ 4.824000000000e-03 7.806108583829e-01
+ 4.825000000000e-03 9.678187866461e-01
+ 4.826000000000e-03 8.945427901468e-01
+ 4.827000000000e-03 6.015833234708e-01
+ 4.828000000000e-03 2.520617358551e-01
+ 4.829000000000e-03 4.059345859555e-02
+ 4.830000000000e-03 8.492512435390e-02
+ 4.831000000000e-03 3.603726318973e-01
+ 4.832000000000e-03 7.135653815856e-01
+ 4.833000000000e-03 9.478438200559e-01
+ 4.834000000000e-03 9.327604986764e-01
+ 4.835000000000e-03 6.767138889566e-01
+ 4.836000000000e-03 3.222720700887e-01
+ 4.837000000000e-03 6.679008362763e-02
+ 4.838000000000e-03 5.252162360863e-02
+ 4.839000000000e-03 2.874114425131e-01
+ 4.840000000000e-03 6.406716719155e-01
+ 4.841000000000e-03 9.156051853981e-01
+ 4.842000000000e-03 9.591275778773e-01
+ 4.843000000000e-03 7.470053556761e-01
+ 4.844000000000e-03 3.973492713893e-01
+ 4.845000000000e-03 1.048496447550e-01
+ 4.846000000000e-03 3.237178369292e-02
+ 4.847000000000e-03 2.202717368412e-01
+ 4.848000000000e-03 5.639258365406e-01
+ 4.849000000000e-03 8.719856991741e-01
+ 4.850000000000e-03 9.729219967810e-01
+ 4.851000000000e-03 8.105328757761e-01
+ 4.852000000000e-03 4.752374402772e-01
+ 4.853000000000e-03 1.537299263580e-01
+ 4.854000000000e-03 2.502738390389e-02
+ 4.855000000000e-03 1.607920555234e-01
+ 4.856000000000e-03 4.854294684909e-01
+ 4.857000000000e-03 8.181798289111e-01
+ 4.858000000000e-03 9.737660117031e-01
+ 4.859000000000e-03 8.655568240007e-01
+ 4.860000000000e-03 5.538037022846e-01
+ 4.861000000000e-03 2.120924003117e-01
+ 4.862000000000e-03 3.068954185698e-02
+ 4.863000000000e-03 1.106011785848e-01
+ 4.864000000000e-03 4.073320970421e-01
+ 4.865000000000e-03 7.556609840955e-01
+ 4.866000000000e-03 9.616365103031e-01
+ 4.867000000000e-03 9.105704352539e-01
+ 4.868000000000e-03 6.308966141728e-01
+ 4.869000000000e-03 2.783388799802e-01
+ 4.870000000000e-03 4.920320612002e-02
+ 4.871000000000e-03 7.107352323784e-02
+ 4.872000000000e-03 3.317723254249e-01
+ 4.873000000000e-03 6.861411686150e-01
+ 4.874000000000e-03 9.368656444883e-01
+ 4.875000000000e-03 9.443410655595e-01
+ 4.876000000000e-03 7.044050786367e-01
+ 4.877000000000e-03 3.506552846491e-01
+ 4.878000000000e-03 8.006140211162e-02
+ 4.879000000000e-03 4.329150710915e-02
+ 4.880000000000e-03 2.608192677300e-01
+ 4.881000000000e-03 6.115240995754e-01
+ 4.882000000000e-03 9.001317348305e-01
+ 4.883000000000e-03 9.659439465454e-01
+ 4.884000000000e-03 7.723161541818e-01
+ 4.885000000000e-03 4.270613159569e-01
+ 4.886000000000e-03 1.224191149943e-01
+ 4.887000000000e-03 2.801590752488e-02
+ 4.888000000000e-03 1.964158886896e-01
+ 4.889000000000e-03 5.338530762834e-01
+ 4.890000000000e-03 8.524406955671e-01
+ 4.891000000000e-03 9.747875091203e-01
+ 4.892000000000e-03 8.327701771232e-01
+ 4.893000000000e-03 5.054646860027e-01
+ 4.894000000000e-03 1.751164293964e-01
+ 4.895000000000e-03 2.566502853311e-02
+ 4.896000000000e-03 1.403257979094e-01
+ 4.897000000000e-03 4.552550269342e-01
+ 4.898000000000e-03 7.950984888425e-01
+ 4.899000000000e-03 9.706295828863e-01
+ 4.900000000000e-03 8.841116862546e-01
+ 4.901000000000e-03 5.837184121498e-01
+ 4.902000000000e-03 2.367102923096e-01
+ 4.903000000000e-03 3.630324614700e-02
+ 4.904000000000e-03 9.408495552625e-02
+ 4.905000000000e-03 3.778822652254e-01
+ 4.906000000000e-03 7.296753624930e-01
+ 4.907000000000e-03 9.535840276870e-01
+ 4.908000000000e-03 9.249347556750e-01
+ 4.909000000000e-03 6.596796095811e-01
+ 4.910000000000e-03 3.055140293716e-01
+ 4.911000000000e-03 5.963924548441e-02
+ 4.912000000000e-03 5.895961177514e-02
+ 4.913000000000e-03 3.038535518151e-01
+ 4.914000000000e-03 6.579628506861e-01
+ 4.915000000000e-03 9.241176156908e-01
+ 4.916000000000e-03 9.541214943914e-01
+ 4.917000000000e-03 7.312681716396e-01
+ 4.918000000000e-03 3.796435324274e-01
+ 4.919000000000e-03 9.503399807799e-02
+ 4.920000000000e-03 3.591163223754e-02
+ 4.921000000000e-03 2.351960745935e-01
+ 4.922000000000e-03 5.819247148983e-01
+ 4.923000000000e-03 8.830372493926e-01
+ 4.924000000000e-03 9.708726584270e-01
+ 4.925000000000e-03 7.965237310651e-01
+ 4.926000000000e-03 4.570688535832e-01
+ 4.927000000000e-03 1.415182609067e-01
+ 4.928000000000e-03 2.557215830253e-02
+ 4.929000000000e-03 1.737899365634e-01
+ 4.930000000000e-03 5.036431686508e-01
+ 4.931000000000e-03 8.314678655538e-01
+ 4.932000000000e-03 9.747295371638e-01
+ 4.933000000000e-03 8.536593423096e-01
+ 4.934000000000e-03 5.356697929028e-01
+ 4.935000000000e-03 1.978191179578e-01
+ 4.936000000000e-03 2.822432411351e-02
+ 4.937000000000e-03 1.213166714664e-01
+ 4.938000000000e-03 4.252618585820e-01
+ 4.939000000000e-03 7.708216301515e-01
+ 4.940000000000e-03 9.655865145848e-01
+ 4.941000000000e-03 9.011104149072e-01
+ 4.942000000000e-03 6.132939575514e-01
+ 4.943000000000e-03 2.623948375122e-01
+ 4.944000000000e-03 4.379550327772e-02
+ 4.945000000000e-03 7.921319698818e-02
+ 4.946000000000e-03 3.489271632419e-01
+ 4.947000000000e-03 7.027592679011e-01
+ 4.948000000000e-03 9.436939614420e-01
+ 4.949000000000e-03 9.375775579149e-01
+ 4.950000000000e-03 6.878157025005e-01
+ 4.951000000000e-03 3.334770906242e-01
+ 4.952000000000e-03 7.185929765327e-02
+ 4.953000000000e-03 4.863246648502e-02
+ 4.954000000000e-03 2.767294170816e-01
+ 4.955000000000e-03 6.291445852931e-01
+ 4.956000000000e-03 9.096513791526e-01
+ 4.957000000000e-03 9.620621621805e-01
+ 4.958000000000e-03 7.571943387805e-01
+ 4.959000000000e-03 4.091193746996e-01
+ 4.960000000000e-03 1.116472137531e-01
+ 4.961000000000e-03 3.041189673359e-02
+ 4.962000000000e-03 2.106456691399e-01
+ 4.963000000000e-03 5.519934324782e-01
+ 4.964000000000e-03 8.643909831694e-01
+ 4.965000000000e-03 9.738937460632e-01
+ 4.966000000000e-03 8.195300153088e-01
+ 4.967000000000e-03 4.872503161432e-01
+ 4.968000000000e-03 1.620697070211e-01
+ 4.969000000000e-03 2.505043627216e-02
+ 4.970000000000e-03 1.524855439185e-01
+ 4.971000000000e-03 4.734185016209e-01
+ 4.972000000000e-03 8.091521753730e-01
+ 4.973000000000e-03 9.727483157708e-01
+ 4.974000000000e-03 8.731157440430e-01
+ 4.975000000000e-03 5.657303924498e-01
+ 4.976000000000e-03 2.217460177085e-01
+ 4.977000000000e-03 3.269490229132e-02
+ 4.978000000000e-03 1.038416869745e-01
+ 4.979000000000e-03 3.955714733454e-01
+ 4.980000000000e-03 7.454476045332e-01
+ 4.981000000000e-03 9.586572375439e-01
+ 4.982000000000e-03 9.164841438096e-01
+ 4.983000000000e-03 6.424105204732e-01
+ 4.984000000000e-03 2.890419813293e-01
+ 4.985000000000e-03 5.313596022030e-02
+ 4.986000000000e-03 6.604615222589e-02
+ 4.987000000000e-03 3.205840955336e-01
+ 4.988000000000e-03 6.750217442276e-01
+ 4.989000000000e-03 9.320063787278e-01
+ 4.990000000000e-03 9.484476227835e-01
+ 4.991000000000e-03 7.151909065015e-01
+ 4.992000000000e-03 3.621147783043e-01
+ 4.993000000000e-03 8.581385610435e-02
+ 4.994000000000e-03 4.013392524544e-02
+ 4.995000000000e-03 2.505098079548e-01
+ 4.996000000000e-03 5.998031225178e-01
+ 4.997000000000e-03 8.935255412574e-01
+ 4.998000000000e-03 9.681308992733e-01
+ 4.999000000000e-03 7.820785465983e-01
+ 5.000000000000e-03 4.389633973732e-01
+ 5.001000000000e-03 1.298337447983e-01
+ 5.002000000000e-03 2.681458141702e-02
+ 5.003000000000e-03 1.872675112723e-01
+ 5.004000000000e-03 5.218515115119e-01
+ 5.005000000000e-03 8.442684769015e-01
+ 5.006000000000e-03 9.749949702639e-01
+ 5.007000000000e-03 8.412418026362e-01
+ 5.008000000000e-03 5.174834308975e-01
+ 5.009000000000e-03 1.839901942312e-01
+ 5.010000000000e-03 2.645285506166e-02
+ 5.011000000000e-03 1.325890202379e-01
+ 5.012000000000e-03 4.433015229646e-01
+ 5.013000000000e-03 7.855840315308e-01
+ 5.014000000000e-03 9.688518713702e-01
+ 5.015000000000e-03 8.910605595189e-01
+ 5.016000000000e-03 5.955247015502e-01
+ 5.017000000000e-03 2.468001947247e-01
+ 5.018000000000e-03 3.905865162347e-02
+ 5.019000000000e-03 8.797164001578e-02
+ 5.020000000000e-03 3.663041544852e-01
+ 5.021000000000e-03 7.190792085833e-01
+ 5.022000000000e-03 9.498698240175e-01
+ 5.023000000000e-03 9.301705900965e-01
+ 5.024000000000e-03 6.709501423544e-01
+ 5.025000000000e-03 3.165437694412e-01
+ 5.026000000000e-03 6.428677642107e-02
+ 5.027000000000e-03 5.463716426841e-02
+ 5.028000000000e-03 2.929678870366e-01
+ 5.029000000000e-03 6.465751631969e-01
+ 5.030000000000e-03 9.185686288988e-01
+ 5.031000000000e-03 9.575009128985e-01
+ 5.032000000000e-03 7.416943177081e-01
+ 5.033000000000e-03 3.913110738953e-01
+ 5.034000000000e-03 1.014463873918e-01
+ 5.035000000000e-03 3.349841779647e-02
+ 5.036000000000e-03 2.253009467043e-01
+ 5.037000000000e-03 5.700573320488e-01
+ 5.038000000000e-03 8.758054318532e-01
+ 5.039000000000e-03 9.723031196807e-01
+ 5.040000000000e-03 8.058199828730e-01
+ 5.041000000000e-03 4.690546947630e-01
+ 5.042000000000e-03 1.495199129757e-01
+ 5.043000000000e-03 2.513425992212e-02
+ 5.044000000000e-03 1.651563118214e-01
+ 5.045000000000e-03 4.916210645452e-01
+ 5.046000000000e-03 8.227512519521e-01
+ 5.047000000000e-03 9.741718696914e-01
+ 5.048000000000e-03 8.615711331053e-01
+ 5.049000000000e-03 5.476457158508e-01
+ 5.050000000000e-03 2.071909170980e-01
+ 5.051000000000e-03 2.977373311776e-02
+ 5.052000000000e-03 1.141809713719e-01
+ 5.053000000000e-03 4.134142441805e-01
+ 5.054000000000e-03 7.608589145388e-01
+ 5.055000000000e-03 9.630559894438e-01
+ 5.056000000000e-03 9.074210897503e-01
+ 5.057000000000e-03 6.249320159221e-01
+ 5.058000000000e-03 2.728801481983e-01
+ 5.059000000000e-03 4.728979095174e-02
+ 5.060000000000e-03 7.377082416479e-02
+ 5.061000000000e-03 3.375784713128e-01
+ 5.062000000000e-03 6.918232673443e-01
+ 5.063000000000e-03 9.392598740406e-01
+ 5.064000000000e-03 9.421143065126e-01
+ 5.065000000000e-03 6.987972019673e-01
+ 5.066000000000e-03 3.447887851481e-01
+ 5.067000000000e-03 7.720277710322e-02
+ 5.068000000000e-03 4.503245381180e-02
+ 5.069000000000e-03 2.661904179979e-01
+ 5.070000000000e-03 6.175347691045e-01
+ 5.071000000000e-03 9.034351516781e-01
+ 5.072000000000e-03 9.647007510918e-01
+ 5.073000000000e-03 7.672185640982e-01
+ 5.074000000000e-03 4.209476958185e-01
+ 5.075000000000e-03 1.186935601768e-01
+ 5.076000000000e-03 2.875282625742e-02
+ 5.077000000000e-03 2.012049608028e-01
+ 5.078000000000e-03 5.400277216067e-01
+ 5.079000000000e-03 8.565628395858e-01
+ 5.080000000000e-03 9.745619206825e-01
+ 5.081000000000e-03 8.283224650405e-01
+ 5.082000000000e-03 4.992713594119e-01
+ 5.083000000000e-03 1.706259646386e-01
+ 5.084000000000e-03 2.537773965628e-02
+ 5.085000000000e-03 1.444016488489e-01
+ 5.086000000000e-03 4.614245627650e-01
+ 5.087000000000e-03 7.999264800416e-01
+ 5.088000000000e-03 9.714277789344e-01
+ 5.089000000000e-03 8.804356474554e-01
+ 5.090000000000e-03 5.776149759572e-01
+ 5.091000000000e-03 2.315778836251e-01
+ 5.092000000000e-03 3.499961672346e-02
+ 5.093000000000e-03 9.733597298274e-02
+ 5.094000000000e-03 3.838777461945e-01
+ 5.095000000000e-03 7.350769921008e-01
+ 5.096000000000e-03 9.553841505754e-01
+ 5.097000000000e-03 9.221310540910e-01
+ 5.098000000000e-03 6.538331990961e-01
+ 5.099000000000e-03 2.998802216412e-01
+ 5.100000000000e-03 5.735497384884e-02
+ 5.101000000000e-03 6.129677051863e-02
+ 5.102000000000e-03 3.095107988376e-01
+ 5.103000000000e-03 6.637902015282e-01
+ 5.104000000000e-03 9.268703712045e-01
+ 5.105000000000e-03 9.522669060414e-01
+ 5.106000000000e-03 7.258388838303e-01
+ 5.107000000000e-03 3.736626007466e-01
+ 5.108000000000e-03 9.183163628055e-02
+ 5.109000000000e-03 3.727093196768e-02
+ 5.110000000000e-03 2.403601707171e-01
+ 5.111000000000e-03 5.880182119323e-01
+ 5.112000000000e-03 8.866672566100e-01
+ 5.113000000000e-03 9.700179689977e-01
+ 5.114000000000e-03 7.916602404925e-01
+ 5.115000000000e-03 4.509045786221e-01
+ 5.116000000000e-03 1.374855018000e-01
+ 5.117000000000e-03 2.591637621989e-02
+ 5.118000000000e-03 1.783194691847e-01
+ 5.119000000000e-03 5.098359487391e-01
+ 5.120000000000e-03 8.358757210633e-01
+ 5.121000000000e-03 9.748981513045e-01
+ 5.122000000000e-03 8.494948298539e-01
+ 5.123000000000e-03 5.294909759679e-01
+ 5.124000000000e-03 1.930663938331e-01
+ 5.125000000000e-03 2.754403422155e-02
+ 5.126000000000e-03 1.250876047445e-01
+ 5.127000000000e-03 4.313843398391e-01
+ 5.128000000000e-03 7.758866300953e-01
+ 5.129000000000e-03 9.667738149984e-01
+ 5.130000000000e-03 8.977589207675e-01
+ 5.131000000000e-03 6.072697981634e-01
+ 5.132000000000e-03 2.570522960422e-01
+ 5.133000000000e-03 4.210933450249e-02
+ 5.134000000000e-03 8.212226841981e-02
+ 5.135000000000e-03 3.548116888318e-01
+ 5.136000000000e-03 7.083427133057e-01
+ 5.137000000000e-03 9.458674353250e-01
+ 5.138000000000e-03 9.351308587548e-01
+ 5.139000000000e-03 6.821111650693e-01
+ 5.140000000000e-03 3.276910309259e-01
+ 5.141000000000e-03 6.921342371260e-02
+ 5.142000000000e-03 5.060001462398e-02
+ 5.143000000000e-03 2.822148462999e-01
+ 5.144000000000e-03 6.350935801753e-01
+ 5.145000000000e-03 9.127515085188e-01
+ 5.146000000000e-03 9.605872579341e-01
+ 5.147000000000e-03 7.519656352491e-01
+ 5.148000000000e-03 4.030482411062e-01
+ 5.149000000000e-03 1.081140887444e-01
+ 5.150000000000e-03 3.138404262421e-02
+ 5.151000000000e-03 2.155817900602e-01
+ 5.152000000000e-03 5.581450707193e-01
+ 5.153000000000e-03 8.683328746792e-01
+ 5.154000000000e-03 9.734310252214e-01
+ 5.155000000000e-03 8.149203274779e-01
+ 5.156000000000e-03 4.810603593960e-01
+ 5.157000000000e-03 1.577460813525e-01
+ 5.158000000000e-03 2.500055886044e-02
+ 5.159000000000e-03 1.567371867649e-01
+ 5.160000000000e-03 4.796043279557e-01
+ 5.161000000000e-03 8.138278850362e-01
+ 5.162000000000e-03 9.733104493912e-01
+ 5.163000000000e-03 8.692513027077e-01
+ 5.164000000000e-03 5.595911171206e-01
+ 5.165000000000e-03 2.167502887043e-01
+ 5.166000000000e-03 3.162436741061e-02
+ 5.167000000000e-03 1.072924255866e-01
+ 5.168000000000e-03 4.016220963084e-01
+ 5.169000000000e-03 7.507290936256e-01
+ 5.170000000000e-03 9.602288322688e-01
+ 5.171000000000e-03 9.134707720797e-01
+ 5.172000000000e-03 6.364900432841e-01
+ 5.173000000000e-03 2.835109510611e-01
+ 5.174000000000e-03 5.107408318957e-02
+ 5.175000000000e-03 6.860149224866e-02
+ 5.176000000000e-03 3.263338260425e-01
+ 5.177000000000e-03 6.807643854792e-01
+ 5.178000000000e-03 9.345443983128e-01
+ 5.179000000000e-03 9.463678382445e-01
+ 5.180000000000e-03 7.096513526478e-01
+ 5.181000000000e-03 3.561999074292e-01
+ 5.182000000000e-03 8.281709896328e-02
+ 5.183000000000e-03 4.172389174459e-02
+ 5.184000000000e-03 2.558011965079e-01
+ 5.185000000000e-03 6.058496605572e-01
+ 5.186000000000e-03 8.969604850678e-01
+ 5.187000000000e-03 9.670416543406e-01
+ 5.188000000000e-03 7.770716101455e-01
+ 5.189000000000e-03 4.328266575646e-01
+ 5.190000000000e-03 1.259841701613e-01
+ 5.191000000000e-03 2.739563505915e-02
+ 5.192000000000e-03 1.919556595142e-01
+ 5.193000000000e-03 5.280363691175e-01
+ 5.194000000000e-03 8.485062831043e-01
+ 5.195000000000e-03 9.749260926088e-01
+ 5.196000000000e-03 8.369045925586e-01
+ 5.197000000000e-03 5.112928694452e-01
+ 5.198000000000e-03 1.793932181017e-01
+ 5.199000000000e-03 2.600908438689e-02
+ 5.200000000000e-03 1.365455488291e-01
+ 5.201000000000e-03 4.494553351985e-01
+ 5.202000000000e-03 7.905086528650e-01
+ 5.203000000000e-03 9.698052471250e-01
+ 5.204000000000e-03 8.875118451334e-01
+ 5.205000000000e-03 5.894498395848e-01
+ 5.206000000000e-03 2.415816998031e-01
+ 5.207000000000e-03 3.760220876163e-02
+ 5.208000000000e-03 9.108820414697e-02
+ 5.209000000000e-03 3.722584065501e-01
+ 5.210000000000e-03 7.245557901760e-01
+ 5.211000000000e-03 9.518193461258e-01
+ 5.212000000000e-03 9.275075487078e-01
+ 5.213000000000e-03 6.651573327143e-01
+ 5.214000000000e-03 3.108466579774e-01
+ 5.215000000000e-03 6.185754432030e-02
+ 5.216000000000e-03 5.682842055348e-02
+ 5.217000000000e-03 2.985595288523e-01
+ 5.218000000000e-03 6.524537354030e-01
+ 5.219000000000e-03 9.214609120265e-01
+ 5.220000000000e-03 9.557964687140e-01
+ 5.221000000000e-03 7.363421895660e-01
+ 5.222000000000e-03 3.852913544813e-01
+ 5.223000000000e-03 9.811088767137e-02
+ 5.224000000000e-03 3.470436129934e-02
+ 5.225000000000e-03 2.303768578384e-01
+ 5.226000000000e-03 5.761769171902e-01
+ 5.227000000000e-03 8.795612742818e-01
+ 5.228000000000e-03 9.716039468685e-01
+ 5.229000000000e-03 8.010550978649e-01
+ 5.230000000000e-03 4.628772102249e-01
+ 5.231000000000e-03 1.453694843112e-01
+ 5.232000000000e-03 2.532186732052e-02
+ 5.233000000000e-03 1.695774945108e-01
+ 5.234000000000e-03 4.978140850925e-01
+ 5.235000000000e-03 8.272678044228e-01
+ 5.236000000000e-03 9.744971142637e-01
+ 5.237000000000e-03 8.575239719158e-01
+ 5.238000000000e-03 5.414796292233e-01
+ 5.239000000000e-03 2.023392140211e-01
+ 5.240000000000e-03 2.893786700720e-02
+ 5.241000000000e-03 1.178263568099e-01
+ 5.242000000000e-03 4.195111116637e-01
+ 5.243000000000e-03 7.660124966572e-01
+ 5.244000000000e-03 9.643967449666e-01
+ 5.245000000000e-03 9.042024790541e-01
+ 5.246000000000e-03 6.189461781224e-01
+ 5.247000000000e-03 2.674600288021e-01
+ 5.248000000000e-03 4.545334052727e-02
+ 5.249000000000e-03 7.654058782546e-02
+ 5.250000000000e-03 3.434122302985e-01
+ 5.251000000000e-03 6.974727544201e-01
+ 5.252000000000e-03 9.415794255254e-01
+ 5.253000000000e-03 9.398123841192e-01
+ 5.254000000000e-03 6.931555280135e-01
+ 5.255000000000e-03 3.389486729280e-01
+ 5.256000000000e-03 7.441603136596e-02
+ 5.257000000000e-03 4.685074902555e-02
+ 5.258000000000e-03 2.716013179645e-01
+ 5.259000000000e-03 6.235254566822e-01
+ 5.260000000000e-03 9.066699809781e-01
+ 5.261000000000e-03 9.633785523962e-01
+ 5.262000000000e-03 7.620755444924e-01
+ 5.263000000000e-03 4.148475152720e-01
+ 5.264000000000e-03 1.150328308303e-01
+ 5.265000000000e-03 2.956986118184e-02
+ 5.266000000000e-03 2.060448307183e-01
+ 5.267000000000e-03 5.461955618627e-01
+ 5.268000000000e-03 8.606243647647e-01
+ 5.269000000000e-03 9.742556525166e-01
+ 5.270000000000e-03 8.238189352317e-01
+ 5.271000000000e-03 4.930781566962e-01
+ 5.272000000000e-03 1.661914963830e-01
+ 5.273000000000e-03 2.517114076592e-02
+ 5.274000000000e-03 1.485379546566e-01
+ 5.275000000000e-03 4.676006567619e-01
+ 5.276000000000e-03 8.047034810838e-01
+ 5.277000000000e-03 9.721458280860e-01
+ 5.278000000000e-03 8.766949312280e-01
+ 5.279000000000e-03 5.714983445312e-01
+ 5.280000000000e-03 2.264911090767e-01
+ 5.281000000000e-03 3.377504148217e-02
+ 5.282000000000e-03 1.006554468888e-01
+ 5.283000000000e-03 3.898929689746e-01
+ 5.284000000000e-03 7.404386565387e-01
+ 5.285000000000e-03 9.571068541265e-01
+ 5.286000000000e-03 9.192555864904e-01
+ 5.287000000000e-03 6.479606356055e-01
+ 5.288000000000e-03 2.942804360448e-01
+ 5.289000000000e-03 5.514595578680e-02
+ 5.290000000000e-03 6.370851269540e-02
+ 5.291000000000e-03 3.152004307107e-01
+ 5.292000000000e-03 6.695897065856e-01
+ 5.293000000000e-03 9.295505549759e-01
+ 5.294000000000e-03 9.503354283131e-01
+ 5.295000000000e-03 7.203712014110e-01
+ 5.296000000000e-03 3.677031475425e-01
+ 5.297000000000e-03 8.869866671888e-02
+ 5.298000000000e-03 3.870889973633e-02
+ 5.299000000000e-03 2.455684079107e-01
+ 5.300000000000e-03 5.940967450908e-01
+ 5.301000000000e-03 8.902315269706e-01
+ 5.302000000000e-03 9.690833723524e-01
+ 5.303000000000e-03 7.867471650967e-01
+ 5.304000000000e-03 4.447486503171e-01
+ 5.305000000000e-03 1.335143733678e-01
+ 5.306000000000e-03 2.634119255070e-02
+ 5.307000000000e-03 1.829036903442e-01
+ 5.308000000000e-03 5.160270566291e-01
+ 5.309000000000e-03 8.402264747267e-01
+ 5.310000000000e-03 9.749860285547e-01
+ 5.311000000000e-03 8.452709001828e-01
+ 5.312000000000e-03 5.233071453057e-01
+ 5.313000000000e-03 1.883658511388e-01
+ 5.314000000000e-03 2.694406602675e-02
+ 5.315000000000e-03 1.289222764493e-01
+ 5.316000000000e-03 4.375184863657e-01
+ 5.317000000000e-03 7.809047268693e-01
+ 5.318000000000e-03 9.678817597308e-01
+ 5.319000000000e-03 8.943398040897e-01
+ 5.320000000000e-03 6.012274019604e-01
+ 5.321000000000e-03 2.517510578331e-01
+ 5.322000000000e-03 4.050101119446e-02
+ 5.323000000000e-03 8.510238276570e-02
+ 5.324000000000e-03 3.607208977199e-01
+ 5.325000000000e-03 7.138907386041e-01
+ 5.326000000000e-03 9.479651077964e-01
+ 5.327000000000e-03 9.326101834962e-01
+ 5.328000000000e-03 6.763756671275e-01
+ 5.329000000000e-03 3.219342652777e-01
+ 5.330000000000e-03 6.664078730408e-02
+ 5.331000000000e-03 5.264396473934e-02
+ 5.332000000000e-03 2.877373009227e-01
+ 5.333000000000e-03 6.410196079526e-01
+ 5.334000000000e-03 9.157814664742e-01
+ 5.335000000000e-03 9.590340497760e-01
+ 5.336000000000e-03 7.466940953289e-01
+ 5.337000000000e-03 3.969935901700e-01
+ 5.338000000000e-03 1.046475878104e-01
+ 5.339000000000e-03 3.243585737657e-02
+ 5.340000000000e-03 2.205662645942e-01
+ 5.341000000000e-03 5.642868237833e-01
+ 5.342000000000e-03 8.722121463394e-01
+ 5.343000000000e-03 9.728878169137e-01
+ 5.344000000000e-03 8.102571004033e-01
+ 5.345000000000e-03 4.748736225554e-01
+ 5.346000000000e-03 1.534806418803e-01
+ 5.347000000000e-03 2.503143555926e-02
+ 5.348000000000e-03 1.610471873289e-01
+ 5.349000000000e-03 4.857936217350e-01
+ 5.350000000000e-03 8.184502411804e-01
+ 5.351000000000e-03 9.737921160447e-01
+ 5.352000000000e-03 8.653240853818e-01
+ 5.353000000000e-03 5.534417107742e-01
+ 5.354000000000e-03 2.118027146590e-01
+ 5.355000000000e-03 3.063346053437e-02
+ 5.356000000000e-03 1.108099279634e-01
+ 5.357000000000e-03 4.076894443862e-01
+ 5.358000000000e-03 7.559679565520e-01
+ 5.359000000000e-03 9.617221840174e-01
+ 5.360000000000e-03 9.103871066579e-01
+ 5.361000000000e-03 6.305463615790e-01
+ 5.362000000000e-03 2.780167258479e-01
+ 5.363000000000e-03 4.908852753945e-02
+ 5.364000000000e-03 7.123017383715e-02
+ 5.365000000000e-03 3.321130813386e-01
+ 5.366000000000e-03 6.864762951847e-01
+ 5.367000000000e-03 9.370085415029e-01
+ 5.368000000000e-03 9.442121672211e-01
+ 5.369000000000e-03 7.040761562082e-01
+ 5.370000000000e-03 3.503094838430e-01
+ 5.371000000000e-03 7.989126660884e-02
+ 5.372000000000e-03 4.339176923962e-02
+ 5.373000000000e-03 2.611341010199e-01
+ 5.374000000000e-03 6.118782032169e-01
+ 5.375000000000e-03 9.003279420812e-01
+ 5.376000000000e-03 9.658730081916e-01
+ 5.377000000000e-03 7.720175690660e-01
+ 5.378000000000e-03 4.267013378189e-01
+ 5.379000000000e-03 1.221981815270e-01
+ 5.380000000000e-03 2.805703562765e-02
+ 5.381000000000e-03 1.966961780213e-01
+ 5.382000000000e-03 5.342164602921e-01
+ 5.383000000000e-03 8.526848401534e-01
+ 5.384000000000e-03 9.747764733130e-01
+ 5.385000000000e-03 8.325101057173e-01
+ 5.386000000000e-03 5.051003881046e-01
+ 5.387000000000e-03 1.748507479638e-01
+ 5.388000000000e-03 2.564589636439e-02
+ 5.389000000000e-03 1.405638678951e-01
+ 5.390000000000e-03 4.556177404730e-01
+ 5.391000000000e-03 7.953838851559e-01
+ 5.392000000000e-03 9.706787518282e-01
+ 5.393000000000e-03 8.838972503033e-01
+ 5.394000000000e-03 5.833597703545e-01
+ 5.395000000000e-03 2.364071382804e-01
+ 5.396000000000e-03 3.622437761831e-02
+ 5.397000000000e-03 9.427428690375e-02
+ 5.398000000000e-03 3.782343758169e-01
+ 5.399000000000e-03 7.299941952967e-01
+ 5.400000000000e-03 9.536920549451e-01
+ 5.401000000000e-03 9.247718272508e-01
+ 5.402000000000e-03 6.593364448655e-01
+ 5.403000000000e-03 3.051817042564e-01
+ 5.404000000000e-03 5.950280031622e-02
+ 5.405000000000e-03 5.909501993072e-02
+ 5.406000000000e-03 3.041854173314e-01
+ 5.407000000000e-03 6.583063891240e-01
+ 5.408000000000e-03 9.242815430677e-01
+ 5.409000000000e-03 9.540145350943e-01
+ 5.410000000000e-03 7.309498811592e-01
+ 5.411000000000e-03 3.792911365526e-01
+ 5.412000000000e-03 9.484371265812e-02
+ 5.413000000000e-03 3.598940918036e-02
+ 5.414000000000e-03 2.354986072939e-01
+ 5.415000000000e-03 5.822835515813e-01
+ 5.416000000000e-03 8.832525879332e-01
+ 5.417000000000e-03 9.708245972097e-01
+ 5.418000000000e-03 7.962390308248e-01
+ 5.419000000000e-03 4.567060368897e-01
+ 5.420000000000e-03 1.412793459743e-01
+ 5.421000000000e-03 2.559017420418e-02
+ 5.422000000000e-03 1.740548519518e-01
+ 5.423000000000e-03 5.040074772649e-01
+ 5.424000000000e-03 8.317287184691e-01
+ 5.425000000000e-03 9.747416901255e-01
+ 5.426000000000e-03 8.534160284856e-01
+ 5.427000000000e-03 5.353064906915e-01
+ 5.428000000000e-03 1.975381159130e-01
+ 5.429000000000e-03 2.818208562994e-02
+ 5.430000000000e-03 1.215367151508e-01
+ 5.431000000000e-03 4.256216629705e-01
+ 5.432000000000e-03 7.711208542960e-01
+ 5.433000000000e-03 9.656585489310e-01
+ 5.434000000000e-03 9.009151503580e-01
+ 5.435000000000e-03 6.129401184194e-01
+ 5.436000000000e-03 2.620794432600e-01
+ 5.437000000000e-03 4.369416705935e-02
+ 5.438000000000e-03 7.938234333532e-02
+ 5.439000000000e-03 3.492726105916e-01
+ 5.440000000000e-03 7.030886693790e-01
+ 5.441000000000e-03 9.438239045981e-01
+ 5.442000000000e-03 9.374356897265e-01
+ 5.443000000000e-03 6.874810159098e-01
+ 5.444000000000e-03 3.331359408594e-01
+ 5.445000000000e-03 7.170163867131e-02
+ 5.446000000000e-03 4.874608362397e-02
+ 5.447000000000e-03 2.770510477293e-01
+ 5.448000000000e-03 6.294951438386e-01
+ 5.449000000000e-03 9.098356727808e-01
+ 5.450000000000e-03 9.619775752440e-01
+ 5.451000000000e-03 7.568879697239e-01
+ 5.452000000000e-03 4.087618114019e-01
+ 5.453000000000e-03 1.114375493109e-01
+ 5.454000000000e-03 3.046687339494e-02
+ 5.455000000000e-03 2.109346756153e-01
+ 5.456000000000e-03 5.523555484644e-01
+ 5.457000000000e-03 8.646245806086e-01
+ 5.458000000000e-03 9.738687566908e-01
+ 5.459000000000e-03 8.192603533370e-01
+ 5.460000000000e-03 4.868861307552e-01
+ 5.461000000000e-03 1.618137785285e-01
+ 5.462000000000e-03 2.504526698565e-02
+ 5.463000000000e-03 1.527340121237e-01
+ 5.464000000000e-03 4.737822589336e-01
+ 5.465000000000e-03 8.094286798364e-01
+ 5.466000000000e-03 9.727836082667e-01
+ 5.467000000000e-03 8.728901735270e-01
+ 5.468000000000e-03 5.653695577539e-01
+ 5.469000000000e-03 2.214508334615e-01
+ 5.470000000000e-03 3.262972861169e-02
+ 5.471000000000e-03 1.040428129049e-01
+ 5.472000000000e-03 3.959269109251e-01
+ 5.473000000000e-03 7.457594442761e-01
+ 5.474000000000e-03 9.587518454651e-01
+ 5.475000000000e-03 9.163088417282e-01
+ 5.476000000000e-03 6.420629174963e-01
+ 5.477000000000e-03 2.887156245959e-01
+ 5.478000000000e-03 5.301256685098e-02
+ 5.479000000000e-03 6.619442828775e-02
+ 5.480000000000e-03 3.209214801468e-01
+ 5.481000000000e-03 6.753603798913e-01
+ 5.482000000000e-03 9.321577113497e-01
+ 5.483000000000e-03 9.483273895749e-01
+ 5.484000000000e-03 7.148660539361e-01
+ 5.485000000000e-03 3.617661859746e-01
+ 5.486000000000e-03 8.563562202544e-02
+ 5.487000000000e-03 4.022529107620e-02
+ 5.488000000000e-03 2.508199007276e-01
+ 5.489000000000e-03 6.001592809697e-01
+ 5.490000000000e-03 8.937294545165e-01
+ 5.491000000000e-03 9.680690273806e-01
+ 5.492000000000e-03 7.817853401441e-01
+ 5.493000000000e-03 4.386021152308e-01
+ 5.494000000000e-03 1.296055507367e-01
+ 5.495000000000e-03 2.684653507246e-02
+ 5.496000000000e-03 1.875418206837e-01
+ 5.497000000000e-03 5.222154397775e-01
+ 5.498000000000e-03 8.445193868770e-01
+ 5.499000000000e-03 9.749931539747e-01
+ 5.500000000000e-03 8.409882714017e-01
+ 5.501000000000e-03 5.171193522226e-01
+ 5.502000000000e-03 1.837182890091e-01
+ 5.503000000000e-03 2.642452152909e-02
+ 5.504000000000e-03 1.328200346525e-01
+ 5.505000000000e-03 4.436632553031e-01
+ 5.506000000000e-03 7.858750673525e-01
+ 5.507000000000e-03 9.689101604214e-01
+ 5.508000000000e-03 8.908536461537e-01
+ 5.509000000000e-03 5.951677962028e-01
+ 5.510000000000e-03 2.464920241416e-01
+ 5.511000000000e-03 3.897080678289e-02
+ 5.512000000000e-03 8.815303337983e-02
+ 5.513000000000e-03 3.666537852886e-01
+ 5.514000000000e-03 7.194024005833e-01
+ 5.515000000000e-03 9.499866222333e-01
+ 5.516000000000e-03 9.300159606761e-01
+ 5.517000000000e-03 6.706101837608e-01
+ 5.518000000000e-03 3.162077723811e-01
+ 5.519000000000e-03 6.414182579857e-02
+ 5.520000000000e-03 5.476396934149e-02
+ 5.521000000000e-03 2.932958420837e-01
+ 5.522000000000e-03 6.469216611482e-01
+ 5.523000000000e-03 9.187407378993e-01
+ 5.524000000000e-03 9.574028017652e-01
+ 5.525000000000e-03 7.413806152282e-01
+ 5.526000000000e-03 3.909564512354e-01
+ 5.527000000000e-03 1.012483002867e-01
+ 5.528000000000e-03 3.356716217292e-02
+ 5.529000000000e-03 2.255982453371e-01
+ 5.530000000000e-03 5.704176475185e-01
+ 5.531000000000e-03 8.760281386392e-01
+ 5.532000000000e-03 9.722642134903e-01
+ 5.533000000000e-03 8.055411268745e-01
+ 5.534000000000e-03 4.686911574217e-01
+ 5.535000000000e-03 1.492741137670e-01
+ 5.536000000000e-03 2.514306111930e-02
+ 5.537000000000e-03 1.654148128720e-01
+ 5.538000000000e-03 4.919853307247e-01
+ 5.539000000000e-03 8.230184579640e-01
+ 5.540000000000e-03 9.741932338436e-01
+ 5.541000000000e-03 8.613347597269e-01
+ 5.542000000000e-03 5.472832188639e-01
+ 5.543000000000e-03 2.069041367036e-01
+ 5.544000000000e-03 2.972235012547e-02
+ 5.545000000000e-03 1.143935960981e-01
+ 5.546000000000e-03 4.137724860755e-01
+ 5.547000000000e-03 7.611633026595e-01
+ 5.548000000000e-03 9.631370389068e-01
+ 5.549000000000e-03 9.072336717944e-01
+ 5.550000000000e-03 6.245804858368e-01
+ 5.551000000000e-03 2.725602397568e-01
+ 5.552000000000e-03 4.717963083191e-02
+ 5.553000000000e-03 7.393175009250e-02
+ 5.554000000000e-03 3.379208788978e-01
+ 5.555000000000e-03 6.921565022688e-01
+ 5.556000000000e-03 9.393983893717e-01
+ 5.557000000000e-03 9.419809761964e-01
+ 5.558000000000e-03 6.984662650147e-01
+ 5.559000000000e-03 3.444445089694e-01
+ 5.560000000000e-03 7.703685645882e-02
+ 5.561000000000e-03 4.513727417652e-02
+ 5.562000000000e-03 2.665076148492e-01
+ 5.563000000000e-03 6.178877255915e-01
+ 5.564000000000e-03 9.036273398003e-01
+ 5.565000000000e-03 9.646251595064e-01
+ 5.566000000000e-03 7.669172825914e-01
+ 5.567000000000e-03 4.205884794950e-01
+ 5.568000000000e-03 1.184764225469e-01
+ 5.569000000000e-03 2.879867067862e-02
+ 5.570000000000e-03 2.014882608639e-01
+ 5.571000000000e-03 5.403907343653e-01
+ 5.572000000000e-03 8.568034376569e-01
+ 5.573000000000e-03 9.745461378132e-01
+ 5.574000000000e-03 8.280590892141e-01
+ 5.575000000000e-03 4.989070396534e-01
+ 5.576000000000e-03 1.703635560777e-01
+ 5.577000000000e-03 2.536335273933e-02
+ 5.578000000000e-03 1.446432942858e-01
+ 5.579000000000e-03 4.617876911245e-01
+ 5.580000000000e-03 8.002088995711e-01
+ 5.581000000000e-03 9.714722369763e-01
+ 5.582000000000e-03 8.802173895415e-01
+ 5.583000000000e-03 5.772555292254e-01
+ 5.584000000000e-03 2.312773898782e-01
+ 5.585000000000e-03 3.492539243696e-02
+ 5.586000000000e-03 9.752934662419e-02
+ 5.587000000000e-03 3.842310463184e-01
+ 5.588000000000e-03 7.353934993672e-01
+ 5.589000000000e-03 9.554876320981e-01
+ 5.590000000000e-03 9.219638908223e-01
+ 5.591000000000e-03 6.534884684104e-01
+ 5.592000000000e-03 2.995498713702e-01
+ 5.593000000000e-03 5.722294473598e-02
+ 5.594000000000e-03 6.143657705817e-02
+ 5.595000000000e-03 3.098445960236e-01
+ 5.596000000000e-03 6.641321293573e-01
+ 5.597000000000e-03 9.270300424902e-01
+ 5.598000000000e-03 9.521554149838e-01
+ 5.599000000000e-03 7.255183092279e-01
+ 5.600000000000e-03 3.733114401996e-01
+ 5.601000000000e-03 9.164541780111e-02
+ 5.602000000000e-03 3.735334297016e-02
+ 5.603000000000e-03 2.406653243283e-01
+ 5.604000000000e-03 5.883761970399e-01
+ 5.605000000000e-03 8.868787452513e-01
+ 5.606000000000e-03 9.699652032009e-01
+ 5.607000000000e-03 7.913726005268e-01
+ 5.608000000000e-03 4.505422239111e-01
+ 5.609000000000e-03 1.372501933247e-01
+ 5.610000000000e-03 2.593913495852e-02
+ 5.611000000000e-03 1.785876229537e-01
+ 5.612000000000e-03 5.102001881305e-01
+ 5.613000000000e-03 8.361332356962e-01
+ 5.614000000000e-03 9.749055556967e-01
+ 5.615000000000e-03 8.492480012017e-01
+ 5.616000000000e-03 5.291273497440e-01
+ 5.617000000000e-03 1.927884390033e-01
+ 5.618000000000e-03 2.750651747549e-02
+ 5.619000000000e-03 1.253114156010e-01
+ 5.620000000000e-03 4.317448592536e-01
+ 5.621000000000e-03 7.761831189893e-01
+ 5.622000000000e-03 9.668411868193e-01
+ 5.623000000000e-03 8.975596625366e-01
+ 5.624000000000e-03 6.069148578964e-01
+ 5.625000000000e-03 2.567393063186e-01
+ 5.626000000000e-03 4.201256962295e-02
+ 5.627000000000e-03 8.229560757076e-02
+ 5.628000000000e-03 3.551586158751e-01
+ 5.629000000000e-03 7.086700574660e-01
+ 5.630000000000e-03 9.459929296777e-01
+ 5.631000000000e-03 9.349846273935e-01
+ 5.632000000000e-03 6.817746303736e-01
+ 5.633000000000e-03 3.273515771584e-01
+ 5.634000000000e-03 6.906006049032e-02
+ 5.635000000000e-03 5.071813538361e-02
+ 5.636000000000e-03 2.825386807903e-01
+ 5.637000000000e-03 6.354428156739e-01
+ 5.638000000000e-03 9.129316888905e-01
+ 5.639000000000e-03 9.604980578138e-01
+ 5.640000000000e-03 7.516567217262e-01
+ 5.641000000000e-03 4.026916188311e-01
+ 5.642000000000e-03 1.079083268481e-01
+ 5.643000000000e-03 3.144371039668e-02
+ 5.644000000000e-03 2.158736641765e-01
+ 5.645000000000e-03 5.585066341591e-01
+ 5.646000000000e-03 8.685628070454e-01
+ 5.647000000000e-03 9.734012989809e-01
+ 5.648000000000e-03 8.146474943556e-01
+ 5.649000000000e-03 4.806963342883e-01
+ 5.650000000000e-03 1.574935553259e-01
+ 5.651000000000e-03 2.500013971513e-02
+ 5.652000000000e-03 1.569891078833e-01
+ 5.653000000000e-03 4.799683183538e-01
+ 5.654000000000e-03 8.141012729740e-01
+ 5.655000000000e-03 9.733410110480e-01
+ 5.656000000000e-03 8.690220211951e-01
+ 5.657000000000e-03 5.592296575730e-01
+ 5.658000000000e-03 2.164579136705e-01
+ 5.659000000000e-03 3.156387282525e-02
+ 5.660000000000e-03 1.074974951483e-01
+ 5.661000000000e-03 4.019785462220e-01
+ 5.662000000000e-03 7.510384507321e-01
+ 5.663000000000e-03 9.603188449284e-01
+ 5.664000000000e-03 9.132913207767e-01
+ 5.665000000000e-03 6.361410474338e-01
+ 5.666000000000e-03 2.831867333616e-01
+ 5.667000000000e-03 5.095516973618e-02
+ 5.668000000000e-03 6.875409466810e-02
+ 5.669000000000e-03 3.266729745171e-01
+ 5.670000000000e-03 6.811012403803e-01
+ 5.671000000000e-03 9.346913970863e-01
+ 5.672000000000e-03 9.462431312111e-01
+ 5.673000000000e-03 7.093243773301e-01
+ 5.674000000000e-03 3.558527253785e-01
+ 5.675000000000e-03 8.264302294472e-02
+ 5.676000000000e-03 4.181984818726e-02
+ 5.677000000000e-03 2.561137563674e-01
+ 5.678000000000e-03 6.062047888838e-01
+ 5.679000000000e-03 8.971604445691e-01
+ 5.680000000000e-03 9.669751065299e-01
+ 5.681000000000e-03 7.767756091889e-01
+ 5.682000000000e-03 4.324660183286e-01
+ 5.683000000000e-03 1.257596984416e-01
+ 5.684000000000e-03 2.743231787243e-02
+ 5.685000000000e-03 1.922330716801e-01
+ 5.686000000000e-03 5.284000461047e-01
+ 5.687000000000e-03 8.487537276812e-01
+ 5.688000000000e-03 9.749195263530e-01
+ 5.689000000000e-03 8.366476715955e-01
+ 5.690000000000e-03 5.109286486982e-01
+ 5.691000000000e-03 1.791244975703e-01
+ 5.692000000000e-03 2.598548905567e-02
+ 5.693000000000e-03 1.367802167009e-01
+ 5.694000000000e-03 4.498176019856e-01
+ 5.695000000000e-03 7.907968065432e-01
+ 5.696000000000e-03 9.698588422332e-01
+ 5.697000000000e-03 8.873010396372e-01
+ 5.698000000000e-03 5.890920110768e-01
+ 5.699000000000e-03 2.412760890510e-01
+ 5.700000000000e-03 3.751898141600e-02
+ 5.701000000000e-03 9.127370162467e-02
+ 5.702000000000e-03 3.726093428947e-01
+ 5.703000000000e-03 7.248767622122e-01
+ 5.704000000000e-03 9.519316349602e-01
+ 5.705000000000e-03 9.273486313356e-01
+ 5.706000000000e-03 6.648156951520e-01
+ 5.707000000000e-03 3.105125257901e-01
+ 5.708000000000e-03 6.171696404150e-02
+ 5.709000000000e-03 5.695966801079e-02
+ 5.710000000000e-03 2.988895247815e-01
+ 5.711000000000e-03 6.527987363604e-01
+ 5.712000000000e-03 9.216288196912e-01
+ 5.713000000000e-03 9.556937912282e-01
+ 5.714000000000e-03 7.360260982860e-01
+ 5.715000000000e-03 3.849378506698e-01
+ 5.716000000000e-03 9.791680408251e-02
+ 5.717000000000e-03 3.477776468135e-02
+ 5.718000000000e-03 2.306768768078e-01
+ 5.719000000000e-03 5.765364996302e-01
+ 5.720000000000e-03 8.797802028260e-01
+ 5.721000000000e-03 9.715603209693e-01
+ 5.722000000000e-03 8.007732086491e-01
+ 5.723000000000e-03 4.625140150684e-01
+ 5.724000000000e-03 1.451272121597e-01
+ 5.725000000000e-03 2.533541656323e-02
+ 5.726000000000e-03 1.698393208592e-01
+ 5.727000000000e-03 4.981784022789e-01
+ 5.728000000000e-03 8.275317587498e-01
+ 5.729000000000e-03 9.745137345943e-01
+ 5.730000000000e-03 8.572840039634e-01
+ 5.731000000000e-03 5.411166883873e-01
+ 5.732000000000e-03 2.020553876399e-01
+ 5.733000000000e-03 2.889119108080e-02
+ 5.734000000000e-03 1.180428207355e-01
+ 5.735000000000e-03 4.198701872061e-01
+ 5.736000000000e-03 7.663142486936e-01
+ 5.737000000000e-03 9.644731563990e-01
+ 5.738000000000e-03 9.040110036013e-01
+ 5.739000000000e-03 6.185934303090e-01
+ 5.740000000000e-03 2.671424204382e-01
+ 5.741000000000e-03 4.534771759617e-02
+ 5.742000000000e-03 7.670576172247e-02
+ 5.743000000000e-03 3.437562313421e-01
+ 5.744000000000e-03 6.978040410461e-01
+ 5.745000000000e-03 9.417135356239e-01
+ 5.746000000000e-03 9.396746444923e-01
+ 5.747000000000e-03 6.928226327995e-01
+ 5.748000000000e-03 3.386059799070e-01
+ 5.749000000000e-03 7.425435378801e-02
+ 5.750000000000e-03 4.696010980406e-02
+ 5.751000000000e-03 2.719208244513e-01
+ 5.752000000000e-03 6.238772060094e-01
+ 5.753000000000e-03 9.068581172977e-01
+ 5.754000000000e-03 9.632983204305e-01
+ 5.755000000000e-03 7.617716178156e-01
+ 5.756000000000e-03 4.144891218327e-01
+ 5.757000000000e-03 1.148195259528e-01
+ 5.758000000000e-03 2.962041412750e-02
+ 5.759000000000e-03 2.063310933448e-01
+ 5.760000000000e-03 5.465581416561e-01
+ 5.761000000000e-03 8.608613754170e-01
+ 5.762000000000e-03 9.742351252685e-01
+ 5.763000000000e-03 8.235522997610e-01
+ 5.764000000000e-03 4.927138770147e-01
+ 5.765000000000e-03 1.659324053052e-01
+ 5.766000000000e-03 2.516150154663e-02
+ 5.767000000000e-03 1.487831344627e-01
+ 5.768000000000e-03 4.679641382071e-01
+ 5.769000000000e-03 8.049828758157e-01
+ 5.770000000000e-03 9.721855676698e-01
+ 5.771000000000e-03 8.764728884574e-01
+ 5.772000000000e-03 5.711381539723e-01
+ 5.773000000000e-03 2.261933266985e-01
+ 5.774000000000e-03 3.370547405647e-02
+ 5.775000000000e-03 1.008528299189e-01
+ 5.776000000000e-03 3.902473985665e-01
+ 5.777000000000e-03 7.407527844587e-01
+ 5.778000000000e-03 9.572057723210e-01
+ 5.779000000000e-03 9.190842167962e-01
+ 5.780000000000e-03 6.476143975563e-01
+ 5.781000000000e-03 2.939521167810e-01
+ 5.782000000000e-03 5.501836517554e-02
+ 5.783000000000e-03 6.385269385045e-02
+ 5.784000000000e-03 3.155361028178e-01
+ 5.785000000000e-03 6.699299656759e-01
+ 5.786000000000e-03 9.297059430245e-01
+ 5.787000000000e-03 9.502194244496e-01
+ 5.788000000000e-03 7.200483971875e-01
+ 5.789000000000e-03 3.673532820235e-01
+ 5.790000000000e-03 8.851654683855e-02
+ 5.791000000000e-03 3.879593078784e-02
+ 5.792000000000e-03 2.458761305533e-01
+ 5.793000000000e-03 5.944538177625e-01
+ 5.794000000000e-03 8.904391297574e-01
+ 5.795000000000e-03 9.690259109467e-01
+ 5.796000000000e-03 7.864566343067e-01
+ 5.797000000000e-03 4.443868191923e-01
+ 5.798000000000e-03 1.332827113539e-01
+ 5.799000000000e-03 2.636869025715e-02
+ 5.800000000000e-03 1.831750369054e-01
+ 5.801000000000e-03 5.163911648742e-01
+ 5.802000000000e-03 8.404806072975e-01
+ 5.803000000000e-03 9.749886831188e-01
+ 5.804000000000e-03 8.450205986652e-01
+ 5.805000000000e-03 5.229432568891e-01
+ 5.806000000000e-03 1.880909907790e-01
+ 5.807000000000e-03 2.691127739638e-02
+ 5.808000000000e-03 1.291498164281e-01
+ 5.809000000000e-03 4.378796595145e-01
+ 5.810000000000e-03 7.811984301068e-01
+ 5.811000000000e-03 9.679444575725e-01
+ 5.812000000000e-03 8.941365860525e-01
+ 5.813000000000e-03 6.008714209005e-01
+ 5.814000000000e-03 2.514405258493e-01
+ 5.815000000000e-03 4.040883410474e-02
+ 5.816000000000e-03 8.527988525118e-02
+ 5.817000000000e-03 3.610692454768e-01
+ 5.818000000000e-03 7.142159697962e-01
+ 5.819000000000e-03 9.480861320103e-01
+ 5.820000000000e-03 9.324596138227e-01
+ 5.821000000000e-03 6.760373415409e-01
+ 5.822000000000e-03 3.215965652179e-01
+ 5.823000000000e-03 6.649174591449e-02
+ 5.824000000000e-03 5.276656903794e-02
+ 5.825000000000e-03 2.880632842006e-01
+ 5.826000000000e-03 6.413674610313e-01
+ 5.827000000000e-03 9.159575029570e-01
+ 5.828000000000e-03 9.589402516367e-01
+ 5.829000000000e-03 7.463826898574e-01
+ 5.830000000000e-03 3.966379695467e-01
+ 5.831000000000e-03 1.044457634415e-01
+ 5.832000000000e-03 3.250020611613e-02
+ 5.833000000000e-03 2.208609567304e-01
+ 5.834000000000e-03 5.646477732080e-01
+ 5.835000000000e-03 8.724383745421e-01
+ 5.836000000000e-03 9.728533588587e-01
+ 5.837000000000e-03 8.099811425144e-01
+ 5.838000000000e-03 4.745098196155e-01
+ 5.839000000000e-03 1.532315612514e-01
+ 5.840000000000e-03 2.503576662640e-02
+ 5.841000000000e-03 1.613025185318e-01
+ 5.842000000000e-03 4.861577833369e-01
+ 5.843000000000e-03 8.187204661139e-01
+ 5.844000000000e-03 9.738179416666e-01
+ 5.845000000000e-03 8.650911318521e-01
+ 5.846000000000e-03 5.530796878255e-01
+ 5.847000000000e-03 2.115131985450e-01
+ 5.848000000000e-03 3.057765532793e-02
+ 5.849000000000e-03 1.110189062925e-01
+ 5.850000000000e-03 4.080468460342e-01
+ 5.851000000000e-03 7.562747784292e-01
+ 5.852000000000e-03 9.618075861124e-01
+ 5.853000000000e-03 9.102035366417e-01
+ 5.854000000000e-03 6.301960321879e-01
+ 5.855000000000e-03 2.776947023023e-01
+ 5.856000000000e-03 4.897411421841e-02
+ 5.857000000000e-03 7.138707667069e-02
+ 5.858000000000e-03 3.324539360159e-01
+ 5.859000000000e-03 6.868113120546e-01
+ 5.860000000000e-03 9.371511814367e-01
+ 5.861000000000e-03 9.440830075641e-01
+ 5.862000000000e-03 7.037471137266e-01
+ 5.863000000000e-03 3.499637710954e-01
+ 5.864000000000e-03 7.972137824550e-02
+ 5.865000000000e-03 4.349229998076e-02
+ 5.866000000000e-03 2.614490748279e-01
+ 5.867000000000e-03 6.122322410436e-01
+ 5.868000000000e-03 9.005239138299e-01
+ 5.869000000000e-03 9.658017957766e-01
+ 5.870000000000e-03 7.717188239297e-01
+ 5.871000000000e-03 4.263414028013e-01
+ 5.872000000000e-03 1.219774703111e-01
+ 5.873000000000e-03 2.809844136241e-02
+ 5.874000000000e-03 1.969766457795e-01
+ 5.875000000000e-03 5.345798241721e-01
+ 5.876000000000e-03 8.529287772641e-01
+ 5.877000000000e-03 9.747651582070e-01
+ 5.878000000000e-03 8.322498387043e-01
+ 5.879000000000e-03 5.047360872062e-01
+ 5.880000000000e-03 1.745852578081e-01
+ 5.881000000000e-03 2.562704324596e-02
+ 5.882000000000e-03 1.408021493280e-01
+ 5.883000000000e-03 4.559804801201e-01
+ 5.884000000000e-03 7.956691077025e-01
+ 5.885000000000e-03 9.707276438818e-01
+ 5.886000000000e-03 8.836825885151e-01
+ 5.887000000000e-03 5.830010795206e-01
+ 5.888000000000e-03 2.361041393159e-01
+ 5.889000000000e-03 3.614578191687e-02
+ 5.890000000000e-03 9.446385695923e-02
+ 5.891000000000e-03 3.785865580401e-01
+ 5.892000000000e-03 7.303128928001e-01
+ 5.893000000000e-03 9.537998153079e-01
+ 5.894000000000e-03 9.246086489441e-01
+ 5.895000000000e-03 6.589931864162e-01
+ 5.896000000000e-03 3.048494937478e-01
+ 5.897000000000e-03 5.936661428117e-02
+ 5.898000000000e-03 5.923068745910e-02
+ 5.899000000000e-03 3.045173980406e-01
+ 5.900000000000e-03 6.586498344345e-01
+ 5.901000000000e-03 9.244452208510e-01
+ 5.902000000000e-03 9.539073087121e-01
+ 5.903000000000e-03 7.306314548174e-01
+ 5.904000000000e-03 3.789388116883e-01
+ 5.905000000000e-03 9.465366558159e-02
+ 5.906000000000e-03 3.606745908885e-02
+ 5.907000000000e-03 2.358012955943e-01
+ 5.908000000000e-03 5.826423398589e-01
+ 5.909000000000e-03 8.834677010159e-01
+ 5.910000000000e-03 9.707762590186e-01
+ 5.911000000000e-03 7.959541563153e-01
+ 5.912000000000e-03 4.563432456640e-01
+ 5.913000000000e-03 1.410406420680e-01
+ 5.914000000000e-03 2.560846918890e-02
+ 5.915000000000e-03 1.743199590853e-01
+ 5.916000000000e-03 5.043717835208e-01
+ 5.917000000000e-03 8.319893762369e-01
+ 5.918000000000e-03 9.747535638089e-01
+ 5.919000000000e-03 8.531725067561e-01
+ 5.920000000000e-03 5.349431677101e-01
+ 5.921000000000e-03 1.972572917985e-01
+ 5.922000000000e-03 2.814012470469e-02
+ 5.923000000000e-03 1.217569814754e-01
+ 5.924000000000e-03 4.259815111139e-01
+ 5.925000000000e-03 7.714199189472e-01
+ 5.926000000000e-03 9.657303093423e-01
+ 5.927000000000e-03 9.007196499605e-01
+ 5.928000000000e-03 6.125862128477e-01
+ 5.929000000000e-03 2.617641889703e-01
+ 5.930000000000e-03 4.359309927395e-02
+ 5.931000000000e-03 7.955173712069e-02
+ 5.932000000000e-03 3.496181466104e-01
+ 5.933000000000e-03 7.034179513852e-01
+ 5.934000000000e-03 9.439535866644e-01
+ 5.935000000000e-03 9.372935642060e-01
+ 5.936000000000e-03 6.871462190294e-01
+ 5.937000000000e-03 3.327948892570e-01
+ 5.938000000000e-03 7.154423164652e-02
+ 5.939000000000e-03 4.885996622404e-02
+ 5.940000000000e-03 2.773728095329e-01
+ 5.941000000000e-03 6.298456262055e-01
+ 5.942000000000e-03 9.100197253130e-01
+ 5.943000000000e-03 9.618927165382e-01
+ 5.944000000000e-03 7.565814495472e-01
+ 5.945000000000e-03 4.084043017763e-01
+ 5.946000000000e-03 1.112281134494e-01
+ 5.947000000000e-03 3.052212627054e-02
+ 5.948000000000e-03 2.112238521402e-01
+ 5.949000000000e-03 5.527176336506e-01
+ 5.950000000000e-03 8.648579635485e-01
+ 5.951000000000e-03 9.738434885537e-01
+ 5.952000000000e-03 8.189905035525e-01
+ 5.953000000000e-03 4.865219530818e-01
+ 5.954000000000e-03 1.615580489819e-01
+ 5.955000000000e-03 2.504037710277e-02
+ 5.956000000000e-03 1.529826846166e-01
+ 5.957000000000e-03 4.741460316695e-01
+ 5.958000000000e-03 8.097050022708e-01
+ 5.959000000000e-03 9.728186226362e-01
+ 5.960000000000e-03 8.726643836491e-01
+ 5.961000000000e-03 5.650086846028e-01
+ 5.962000000000e-03 2.211558130778e-01
+ 5.963000000000e-03 3.256482987394e-02
+ 5.964000000000e-03 1.042441717664e-01
+ 5.965000000000e-03 3.962824097286e-01
+ 5.966000000000e-03 7.460711394453e-01
+ 5.967000000000e-03 9.588461835145e-01
+ 5.968000000000e-03 9.161332947430e-01
+ 5.969000000000e-03 6.417152309481e-01
+ 5.970000000000e-03 2.883893921562e-01
+ 5.971000000000e-03 5.288943643278e-02
+ 5.972000000000e-03 6.634295954633e-02
+ 5.973000000000e-03 3.212589701080e-01
+ 5.974000000000e-03 6.756989123957e-01
+ 5.975000000000e-03 9.323087897440e-01
+ 5.976000000000e-03 9.482068926271e-01
+ 5.977000000000e-03 7.145410749712e-01
+ 5.978000000000e-03 3.614176749635e-01
+ 5.979000000000e-03 8.545763170599e-02
+ 5.980000000000e-03 4.031692738057e-02
+ 5.981000000000e-03 2.511301400861e-01
+ 5.982000000000e-03 6.005153804998e-01
+ 5.983000000000e-03 8.939331361548e-01
+ 5.984000000000e-03 9.680068801348e-01
+ 5.985000000000e-03 7.814919679228e-01
+ 5.986000000000e-03 4.382408692071e-01
+ 5.987000000000e-03 1.293775745687e-01
+ 5.988000000000e-03 2.687876707189e-02
+ 5.989000000000e-03 1.878163139062e-01
+ 5.990000000000e-03 5.225793549743e-01
+ 5.991000000000e-03 8.447700941806e-01
+ 5.992000000000e-03 9.749910582592e-01
+ 5.993000000000e-03 8.407345395724e-01
+ 5.994000000000e-03 5.167552634769e-01
+ 5.995000000000e-03 1.834465698474e-01
+ 5.996000000000e-03 2.639646658877e-02
+ 5.997000000000e-03 1.330512650697e-01
+ 5.998000000000e-03 4.440250207832e-01
+ 5.999000000000e-03 7.861659350015e-01
+ 6.000000000000e-03 9.689681736249e-01
+ 6.001000000000e-03 8.906465028594e-01
+ 6.002000000000e-03 5.948108348704e-01
+ 6.003000000000e-03 2.461840026912e-01
+ 6.004000000000e-03 3.888323315385e-02
+ 6.005000000000e-03 8.833466902294e-02
+ 6.006000000000e-03 3.670034945369e-01
+ 6.007000000000e-03 7.197254635144e-01
+ 6.008000000000e-03 9.501031557333e-01
+ 6.009000000000e-03 9.298610782887e-01
+ 6.010000000000e-03 6.702701248015e-01
+ 6.011000000000e-03 3.158718834405e-01
+ 6.012000000000e-03 6.399713157987e-02
+ 6.013000000000e-03 5.489103633538e-02
+ 6.014000000000e-03 2.936239187289e-01
+ 6.015000000000e-03 6.472680726687e-01
+ 6.016000000000e-03 9.189126005652e-01
+ 6.017000000000e-03 9.573044215533e-01
+ 6.018000000000e-03 7.410667707503e-01
+ 6.019000000000e-03 3.906018927231e-01
+ 6.020000000000e-03 1.010504477572e-01
+ 6.021000000000e-03 3.363618093967e-02
+ 6.022000000000e-03 2.258957053934e-01
+ 6.023000000000e-03 5.707779215635e-01
+ 6.024000000000e-03 8.762506242175e-01
+ 6.025000000000e-03 9.722250294790e-01
+ 6.026000000000e-03 8.052620911341e-01
+ 6.027000000000e-03 4.683276384986e-01
+ 6.028000000000e-03 1.490285208814e-01
+ 6.029000000000e-03 2.515214166257e-02
+ 6.030000000000e-03 1.656735107507e-01
+ 6.031000000000e-03 4.923496016193e-01
+ 6.032000000000e-03 8.232854739526e-01
+ 6.033000000000e-03 9.742143190401e-01
+ 6.034000000000e-03 8.610981737845e-01
+ 6.035000000000e-03 5.469206940615e-01
+ 6.036000000000e-03 2.066175287298e-01
+ 6.037000000000e-03 2.967124378536e-02
+ 6.038000000000e-03 1.146064476667e-01
+ 6.039000000000e-03 4.141307786968e-01
+ 6.040000000000e-03 7.614675371445e-01
+ 6.041000000000e-03 9.632178159181e-01
+ 6.042000000000e-03 9.070460142737e-01
+ 6.043000000000e-03 6.242288824638e-01
+ 6.044000000000e-03 2.722404651118e-01
+ 6.045000000000e-03 4.706973709437e-02
+ 6.046000000000e-03 7.409292666510e-02
+ 6.047000000000e-03 3.382633818291e-01
+ 6.048000000000e-03 6.924896241519e-01
+ 6.049000000000e-03 9.395366462158e-01
+ 6.050000000000e-03 9.418473858738e-01
+ 6.051000000000e-03 6.981352113095e-01
+ 6.052000000000e-03 3.441003243001e-01
+ 6.053000000000e-03 7.687118463303e-02
+ 6.054000000000e-03 4.524236212507e-02
+ 6.055000000000e-03 2.668249490581e-01
+ 6.056000000000e-03 6.182406127290e-01
+ 6.057000000000e-03 9.038192904789e-01
+ 6.058000000000e-03 9.645492945940e-01
+ 6.059000000000e-03 7.666158440643e-01
+ 6.060000000000e-03 4.202293098872e-01
+ 6.061000000000e-03 1.182595093574e-01
+ 6.062000000000e-03 2.884479229543e-02
+ 6.063000000000e-03 2.017717365318e-01
+ 6.064000000000e-03 5.407537233633e-01
+ 6.065000000000e-03 8.570438258298e-01
+ 6.066000000000e-03 9.745300757807e-01
+ 6.067000000000e-03 8.277955203991e-01
+ 6.068000000000e-03 4.985427205379e-01
+ 6.069000000000e-03 1.701013414333e-01
+ 6.070000000000e-03 2.534924503888e-02
+ 6.071000000000e-03 1.448851487700e-01
+ 6.072000000000e-03 4.621508419632e-01
+ 6.073000000000e-03 8.004911424954e-01
+ 6.074000000000e-03 9.715164176632e-01
+ 6.075000000000e-03 8.799989079559e-01
+ 6.076000000000e-03 5.768960370460e-01
+ 6.077000000000e-03 2.309770542137e-01
+ 6.078000000000e-03 3.485144174169e-02
+ 6.079000000000e-03 9.772295702841e-02
+ 6.080000000000e-03 3.845844145455e-01
+ 6.081000000000e-03 7.357098681571e-01
+ 6.082000000000e-03 9.555908456692e-01
+ 6.083000000000e-03 9.217964793227e-01
+ 6.084000000000e-03 6.531436474306e-01
+ 6.085000000000e-03 2.992196390190e-01
+ 6.086000000000e-03 5.709117609768e-02
+ 6.087000000000e-03 6.157664159302e-02
+ 6.088000000000e-03 3.101785050732e-01
+ 6.089000000000e-03 6.644739606326e-01
+ 6.090000000000e-03 9.271894625651e-01
+ 6.091000000000e-03 9.520436579349e-01
+ 6.092000000000e-03 7.251976019596e-01
+ 6.093000000000e-03 3.729603541803e-01
+ 6.094000000000e-03 9.145943954615e-02
+ 6.095000000000e-03 3.743602613576e-02
+ 6.096000000000e-03 2.409706304993e-01
+ 6.097000000000e-03 5.887341301582e-01
+ 6.098000000000e-03 8.870900063017e-01
+ 6.099000000000e-03 9.699121609357e-01
+ 6.100000000000e-03 7.910847891542e-01
+ 6.101000000000e-03 4.501798982948e-01
+ 6.102000000000e-03 1.370150982455e-01
+ 6.103000000000e-03 2.596217257496e-02
+ 6.104000000000e-03 1.788559658015e-01
+ 6.105000000000e-03 5.105644215213e-01
+ 6.106000000000e-03 8.363905525905e-01
+ 6.107000000000e-03 9.749126807143e-01
+ 6.108000000000e-03 8.490009670958e-01
+ 6.109000000000e-03 5.287637063850e-01
+ 6.110000000000e-03 1.925106648980e-01
+ 6.111000000000e-03 2.746927868513e-02
+ 6.112000000000e-03 1.255354468771e-01
+ 6.113000000000e-03 4.321054188202e-01
+ 6.114000000000e-03 7.764794454115e-01
+ 6.115000000000e-03 9.669082840096e-01
+ 6.116000000000e-03 8.973601704312e-01
+ 6.117000000000e-03 6.065598547333e-01
+ 6.118000000000e-03 2.564264596995e-01
+ 6.119000000000e-03 4.191607416578e-02
+ 6.120000000000e-03 8.246919244614e-02
+ 6.121000000000e-03 3.555056281257e-01
+ 6.122000000000e-03 7.089972788720e-01
+ 6.123000000000e-03 9.461181616642e-01
+ 6.124000000000e-03 9.348381401420e-01
+ 6.125000000000e-03 6.814379887452e-01
+ 6.126000000000e-03 3.270122249562e-01
+ 6.127000000000e-03 6.890695077891e-02
+ 6.128000000000e-03 5.083652044419e-02
+ 6.129000000000e-03 2.828626432077e-01
+ 6.130000000000e-03 6.357919714951e-01
+ 6.131000000000e-03 9.131116263447e-01
+ 6.132000000000e-03 9.604085867944e-01
+ 6.133000000000e-03 7.513476601602e-01
+ 6.134000000000e-03 4.023350538000e-01
+ 6.135000000000e-03 1.077027956091e-01
+ 6.136000000000e-03 3.150365380877e-02
+ 6.137000000000e-03 2.161657054371e-01
+ 6.138000000000e-03 5.588681631810e-01
+ 6.139000000000e-03 8.687925225956e-01
+ 6.140000000000e-03 9.733712942505e-01
+ 6.141000000000e-03 8.143744761341e-01
+ 6.142000000000e-03 4.803323205363e-01
+ 6.143000000000e-03 1.572412307868e-01
+ 6.144000000000e-03 2.500000000000e-02
+ 6.145000000000e-03 1.572412307863e-01
+ 6.146000000000e-03 4.803323205355e-01
+ 6.147000000000e-03 8.143744761335e-01
+ 6.148000000000e-03 9.733712942505e-01
+ 6.149000000000e-03 8.687925225958e-01
+ 6.150000000000e-03 5.588681631813e-01
+ 6.151000000000e-03 2.161657054378e-01
+ 6.152000000000e-03 3.150365380890e-02
+ 6.153000000000e-03 1.077027956087e-01
+ 6.154000000000e-03 4.023350537993e-01
+ 6.155000000000e-03 7.513476601599e-01
+ 6.156000000000e-03 9.604085867943e-01
+ 6.157000000000e-03 9.131116263451e-01
+ 6.158000000000e-03 6.357919714959e-01
+ 6.159000000000e-03 2.828626432084e-01
+ 6.160000000000e-03 5.083652044430e-02
+ 6.161000000000e-03 6.890695077876e-02
+ 6.162000000000e-03 3.270122249555e-01
+ 6.163000000000e-03 6.814379887444e-01
+ 6.164000000000e-03 9.348381401417e-01
+ 6.165000000000e-03 9.461181616644e-01
+ 6.166000000000e-03 7.089972788723e-01
+ 6.167000000000e-03 3.555056281261e-01
+ 6.168000000000e-03 8.246919244652e-02
+ 6.169000000000e-03 4.191607416557e-02
+ 6.170000000000e-03 2.564264596988e-01
+ 6.171000000000e-03 6.065598547329e-01
+ 6.172000000000e-03 8.973601704310e-01
+ 6.173000000000e-03 9.669082840097e-01
+ 6.174000000000e-03 7.764794454121e-01
+ 6.175000000000e-03 4.321054188210e-01
+ 6.176000000000e-03 1.255354468776e-01
+ 6.177000000000e-03 2.746927868509e-02
+ 6.178000000000e-03 1.925106648974e-01
+ 6.179000000000e-03 5.287637063842e-01
+ 6.180000000000e-03 8.490009670953e-01
+ 6.181000000000e-03 9.749126807143e-01
+ 6.182000000000e-03 8.363905525911e-01
+ 6.183000000000e-03 5.105644215217e-01
+ 6.184000000000e-03 1.788559658021e-01
+ 6.185000000000e-03 2.596217257501e-02
+ 6.186000000000e-03 1.370150982450e-01
+ 6.187000000000e-03 4.501798982940e-01
+ 6.188000000000e-03 7.910847891539e-01
+ 6.189000000000e-03 9.699121609357e-01
+ 6.190000000000e-03 8.870900063022e-01
+ 6.191000000000e-03 5.887341301589e-01
+ 6.192000000000e-03 2.409706305000e-01
+ 6.193000000000e-03 3.743602613584e-02
+ 6.194000000000e-03 9.145943954597e-02
+ 6.195000000000e-03 3.729603541799e-01
+ 6.196000000000e-03 7.251976019589e-01
+ 6.197000000000e-03 9.520436579347e-01
+ 6.198000000000e-03 9.271894625653e-01
+ 6.199000000000e-03 6.644739606329e-01
+ 6.200000000000e-03 3.101785050735e-01
+ 6.201000000000e-03 6.157664159332e-02
+ 6.202000000000e-03 5.709117609739e-02
+ 6.203000000000e-03 2.992196390183e-01
+ 6.204000000000e-03 6.531436474303e-01
+ 6.205000000000e-03 9.217964793226e-01
+ 6.206000000000e-03 9.555908456695e-01
+ 6.207000000000e-03 7.357098681578e-01
+ 6.208000000000e-03 3.845844145463e-01
+ 6.209000000000e-03 9.772295702883e-02
+ 6.210000000000e-03 3.485144174162e-02
+ 6.211000000000e-03 2.309770542130e-01
+ 6.212000000000e-03 5.768960370452e-01
+ 6.213000000000e-03 8.799989079554e-01
+ 6.214000000000e-03 9.715164176633e-01
+ 6.215000000000e-03 8.004911424960e-01
+ 6.216000000000e-03 4.621508419640e-01
+ 6.217000000000e-03 1.448851487706e-01
+ 6.218000000000e-03 2.534924503885e-02
+ 6.219000000000e-03 1.701013414327e-01
+ 6.220000000000e-03 4.985427205371e-01
+ 6.221000000000e-03 8.277955203988e-01
+ 6.222000000000e-03 9.745300757807e-01
+ 6.223000000000e-03 8.570438258304e-01
+ 6.224000000000e-03 5.407537233641e-01
+ 6.225000000000e-03 2.017717365324e-01
+ 6.226000000000e-03 2.884479229547e-02
+ 6.227000000000e-03 1.182595093571e-01
+ 6.228000000000e-03 4.202293098869e-01
+ 6.229000000000e-03 7.666158440636e-01
+ 6.230000000000e-03 9.645492945938e-01
+ 6.231000000000e-03 9.038192904793e-01
+ 6.232000000000e-03 6.182406127294e-01
+ 6.233000000000e-03 2.668249490585e-01
+ 6.234000000000e-03 4.524236212529e-02
+ 6.235000000000e-03 7.687118463267e-02
+ 6.236000000000e-03 3.441003242993e-01
+ 6.237000000000e-03 6.981352113092e-01
+ 6.238000000000e-03 9.418473858737e-01
+ 6.239000000000e-03 9.395366462161e-01
+ 6.240000000000e-03 6.924896241526e-01
+ 6.241000000000e-03 3.382633818298e-01
+ 6.242000000000e-03 7.409292666526e-02
+ 6.243000000000e-03 4.706973709426e-02
+ 6.244000000000e-03 2.722404651111e-01
+ 6.245000000000e-03 6.242288824631e-01
+ 6.246000000000e-03 9.070460142733e-01
+ 6.247000000000e-03 9.632178159182e-01
+ 6.248000000000e-03 7.614675371452e-01
+ 6.249000000000e-03 4.141307786972e-01
+ 6.250000000000e-03 1.146064476671e-01
+ 6.251000000000e-03 2.967124378525e-02
+ 6.252000000000e-03 2.066175287292e-01
+ 6.253000000000e-03 5.469206940607e-01
+ 6.254000000000e-03 8.610981737843e-01
+ 6.255000000000e-03 9.742143190401e-01
+ 6.256000000000e-03 8.232854739532e-01
+ 6.257000000000e-03 4.923496016201e-01
+ 6.258000000000e-03 1.656735107512e-01
+ 6.259000000000e-03 2.515214166259e-02
+ 6.260000000000e-03 1.490285208812e-01
+ 6.261000000000e-03 4.683276384982e-01
+ 6.262000000000e-03 8.052620911335e-01
+ 6.263000000000e-03 9.722250294789e-01
+ 6.264000000000e-03 8.762506242179e-01
+ 6.265000000000e-03 5.707779215638e-01
+ 6.266000000000e-03 2.258957053937e-01
+ 6.267000000000e-03 3.363618093982e-02
+ 6.268000000000e-03 1.010504477568e-01
+ 6.269000000000e-03 3.906018927223e-01
+ 6.270000000000e-03 7.410667707500e-01
+ 6.271000000000e-03 9.573044215532e-01
+ 6.272000000000e-03 9.189126005656e-01
+ 6.273000000000e-03 6.472680726694e-01
+ 6.274000000000e-03 2.936239187296e-01
+ 6.275000000000e-03 5.489103633551e-02
+ 6.276000000000e-03 6.399713157973e-02
+ 6.277000000000e-03 3.158718834402e-01
+ 6.278000000000e-03 6.702701248007e-01
+ 6.279000000000e-03 9.298610782884e-01
+ 6.280000000000e-03 9.501031557335e-01
+ 6.281000000000e-03 7.197254635151e-01
+ 6.282000000000e-03 3.670034945372e-01
+ 6.283000000000e-03 8.833466902333e-02
+ 6.284000000000e-03 3.888323315366e-02
+ 6.285000000000e-03 2.461840026906e-01
+ 6.286000000000e-03 5.948108348696e-01
+ 6.287000000000e-03 8.906465028590e-01
+ 6.288000000000e-03 9.689681736251e-01
+ 6.289000000000e-03 7.861659350021e-01
+ 6.290000000000e-03 4.440250207840e-01
+ 6.291000000000e-03 1.330512650702e-01
+ 6.292000000000e-03 2.639646658871e-02
+ 6.293000000000e-03 1.834465698472e-01
+ 6.294000000000e-03 5.167552634766e-01
+ 6.295000000000e-03 8.407345395718e-01
+ 6.296000000000e-03 9.749910582592e-01
+ 6.297000000000e-03 8.447700941812e-01
+ 6.298000000000e-03 5.225793549747e-01
+ 6.299000000000e-03 1.878163139065e-01
+ 6.300000000000e-03 2.687876707192e-02
+ 6.301000000000e-03 1.293775745682e-01
+ 6.302000000000e-03 4.382408692063e-01
+ 6.303000000000e-03 7.814919679225e-01
+ 6.304000000000e-03 9.680068801347e-01
+ 6.305000000000e-03 8.939331361550e-01
+ 6.306000000000e-03 6.005153805006e-01
+ 6.307000000000e-03 2.511301400867e-01
+ 6.308000000000e-03 4.031692738066e-02
+ 6.309000000000e-03 8.545763170582e-02
+ 6.310000000000e-03 3.614176749631e-01
+ 6.311000000000e-03 7.145410749705e-01
+ 6.312000000000e-03 9.482068926268e-01
+ 6.313000000000e-03 9.323087897443e-01
+ 6.314000000000e-03 6.756989123960e-01
+ 6.315000000000e-03 3.212589701083e-01
+ 6.316000000000e-03 6.634295954665e-02
+ 6.317000000000e-03 5.288943643252e-02
+ 6.318000000000e-03 2.883893921555e-01
+ 6.319000000000e-03 6.417152309473e-01
+ 6.320000000000e-03 9.161332947426e-01
+ 6.321000000000e-03 9.588461835147e-01
+ 6.322000000000e-03 7.460711394460e-01
+ 6.323000000000e-03 3.962824097293e-01
+ 6.324000000000e-03 1.042441717668e-01
+ 6.325000000000e-03 3.256482987380e-02
+ 6.326000000000e-03 2.211558130775e-01
+ 6.327000000000e-03 5.650086846020e-01
+ 6.328000000000e-03 8.726643836486e-01
+ 6.329000000000e-03 9.728186226363e-01
+ 6.330000000000e-03 8.097050022714e-01
+ 6.331000000000e-03 4.741460316699e-01
+ 6.332000000000e-03 1.529826846169e-01
+ 6.333000000000e-03 2.504037710277e-02
+ 6.334000000000e-03 1.615580489814e-01
+ 6.335000000000e-03 4.865219530810e-01
+ 6.336000000000e-03 8.189905035522e-01
+ 6.337000000000e-03 9.738434885537e-01
+ 6.338000000000e-03 8.648579635487e-01
+ 6.339000000000e-03 5.527176336513e-01
+ 6.340000000000e-03 2.112238521408e-01
+ 6.341000000000e-03 3.052212627066e-02
+ 6.342000000000e-03 1.112281134492e-01
+ 6.343000000000e-03 4.084043017760e-01
+ 6.344000000000e-03 7.565814495465e-01
+ 6.345000000000e-03 9.618927165380e-01
+ 6.346000000000e-03 9.100197253134e-01
+ 6.347000000000e-03 6.298456262059e-01
+ 6.348000000000e-03 2.773728095332e-01
+ 6.349000000000e-03 4.885996622428e-02
+ 6.350000000000e-03 7.154423164618e-02
+ 6.351000000000e-03 3.327948892563e-01
+ 6.352000000000e-03 6.871462190287e-01
+ 6.353000000000e-03 9.372935642057e-01
+ 6.354000000000e-03 9.439535866645e-01
+ 6.355000000000e-03 7.034179513859e-01
+ 6.356000000000e-03 3.496181466112e-01
+ 6.357000000000e-03 7.955173712105e-02
+ 6.358000000000e-03 4.359309927374e-02
+ 6.359000000000e-03 2.617641889700e-01
+ 6.360000000000e-03 6.125862128469e-01
+ 6.361000000000e-03 9.007196499601e-01
+ 6.362000000000e-03 9.657303093425e-01
+ 6.363000000000e-03 7.714199189479e-01
+ 6.364000000000e-03 4.259815111143e-01
+ 6.365000000000e-03 1.217569814756e-01
+ 6.366000000000e-03 2.814012470465e-02
+ 6.367000000000e-03 1.972572917979e-01
+ 6.368000000000e-03 5.349431677093e-01
+ 6.369000000000e-03 8.531725067556e-01
+ 6.370000000000e-03 9.747535638089e-01
+ 6.371000000000e-03 8.319893762372e-01
+ 6.372000000000e-03 5.043717835216e-01
+ 6.373000000000e-03 1.743199590858e-01
+ 6.374000000000e-03 2.560846918894e-02
+ 6.375000000000e-03 1.410406420678e-01
+ 6.376000000000e-03 4.563432456637e-01
+ 6.377000000000e-03 7.959541563146e-01
+ 6.378000000000e-03 9.707762590185e-01
+ 6.379000000000e-03 8.834677010164e-01
+ 6.380000000000e-03 5.826423398593e-01
+ 6.381000000000e-03 2.358012955946e-01
+ 6.382000000000e-03 3.606745908892e-02
+ 6.383000000000e-03 9.465366558118e-02
+ 6.384000000000e-03 3.789388116876e-01
+ 6.385000000000e-03 7.306314548167e-01
+ 6.386000000000e-03 9.539073087120e-01
+ 6.387000000000e-03 9.244452208512e-01
+ 6.388000000000e-03 6.586498344353e-01
+ 6.389000000000e-03 3.045173980413e-01
+ 6.390000000000e-03 5.923068745940e-02
+ 6.391000000000e-03 5.936661428088e-02
+ 6.392000000000e-03 3.048494937475e-01
+ 6.393000000000e-03 6.589931864155e-01
+ 6.394000000000e-03 9.246086489438e-01
+ 6.395000000000e-03 9.537998153082e-01
+ 6.396000000000e-03 7.303128928008e-01
+ 6.397000000000e-03 3.785865580408e-01
+ 6.398000000000e-03 9.446385695942e-02
+ 6.399000000000e-03 3.614578191670e-02
+ 6.400000000000e-03 2.361041393153e-01
+ 6.401000000000e-03 5.830010795198e-01
+ 6.402000000000e-03 8.836825885146e-01
+ 6.403000000000e-03 9.707276438819e-01
+ 6.404000000000e-03 7.956691077028e-01
+ 6.405000000000e-03 4.559804801209e-01
+ 6.406000000000e-03 1.408021493285e-01
+ 6.407000000000e-03 2.562704324592e-02
+ 6.408000000000e-03 1.745852578078e-01
+ 6.409000000000e-03 5.047360872058e-01
+ 6.410000000000e-03 8.322498387040e-01
+ 6.411000000000e-03 9.747651582070e-01
+ 6.412000000000e-03 8.529287772646e-01
+ 6.413000000000e-03 5.345798241725e-01
+ 6.414000000000e-03 1.969766457798e-01
+ 6.415000000000e-03 2.809844136245e-02
+ 6.416000000000e-03 1.219774703106e-01
+ 6.417000000000e-03 4.263414028005e-01
+ 6.418000000000e-03 7.717188239290e-01
+ 6.419000000000e-03 9.658017957765e-01
+ 6.420000000000e-03 9.005239138300e-01
+ 6.421000000000e-03 6.122322410443e-01
+ 6.422000000000e-03 2.614490748286e-01
+ 6.423000000000e-03 4.349229998098e-02
+ 6.424000000000e-03 7.972137824514e-02
+ 6.425000000000e-03 3.499637710951e-01
+ 6.426000000000e-03 7.037471137259e-01
+ 6.427000000000e-03 9.440830075638e-01
+ 6.428000000000e-03 9.371511814370e-01
+ 6.429000000000e-03 6.868113120554e-01
+ 6.430000000000e-03 3.324539360167e-01
+ 6.431000000000e-03 7.138707667085e-02
+ 6.432000000000e-03 4.897411421816e-02
+ 6.433000000000e-03 2.776947023016e-01
+ 6.434000000000e-03 6.301960321872e-01
+ 6.435000000000e-03 9.102035366413e-01
+ 6.436000000000e-03 9.618075861125e-01
+ 6.437000000000e-03 7.562747784295e-01
+ 6.438000000000e-03 4.080468460350e-01
+ 6.439000000000e-03 1.110189062930e-01
+ 6.440000000000e-03 3.057765532781e-02
+ 6.441000000000e-03 2.115131985447e-01
+ 6.442000000000e-03 5.530796878251e-01
+ 6.443000000000e-03 8.650911318519e-01
+ 6.444000000000e-03 9.738179416667e-01
+ 6.445000000000e-03 8.187204661144e-01
+ 6.446000000000e-03 4.861577833376e-01
+ 6.447000000000e-03 1.613025185321e-01
+ 6.448000000000e-03 2.503576662641e-02
+ 6.449000000000e-03 1.532315612508e-01
+ 6.450000000000e-03 4.745098196147e-01
+ 6.451000000000e-03 8.099811425138e-01
+ 6.452000000000e-03 9.728533588586e-01
+ 6.453000000000e-03 8.724383745424e-01
+ 6.454000000000e-03 5.646477732088e-01
+ 6.455000000000e-03 2.208609567310e-01
+ 6.456000000000e-03 3.250020611627e-02
+ 6.457000000000e-03 1.044457634410e-01
+ 6.458000000000e-03 3.966379695464e-01
+ 6.459000000000e-03 7.463826898571e-01
+ 6.460000000000e-03 9.589402516365e-01
+ 6.461000000000e-03 9.159575029574e-01
+ 6.462000000000e-03 6.413674610320e-01
+ 6.463000000000e-03 2.880632842013e-01
+ 6.464000000000e-03 5.276656903806e-02
+ 6.465000000000e-03 6.649174591417e-02
+ 6.466000000000e-03 3.215965652172e-01
+ 6.467000000000e-03 6.760373415401e-01
+ 6.468000000000e-03 9.324596138224e-01
+ 6.469000000000e-03 9.480861320104e-01
+ 6.470000000000e-03 7.142159697965e-01
+ 6.471000000000e-03 3.610692454776e-01
+ 6.472000000000e-03 8.527988525156e-02
+ 6.473000000000e-03 4.040883410454e-02
+ 6.474000000000e-03 2.514405258486e-01
+ 6.475000000000e-03 6.008714209002e-01
+ 6.476000000000e-03 8.941365860523e-01
+ 6.477000000000e-03 9.679444575726e-01
+ 6.478000000000e-03 7.811984301074e-01
+ 6.479000000000e-03 4.378796595152e-01
+ 6.480000000000e-03 1.291498164284e-01
+ 6.481000000000e-03 2.691127739635e-02
+ 6.482000000000e-03 1.880909907784e-01
+ 6.483000000000e-03 5.229432568883e-01
+ 6.484000000000e-03 8.450205986646e-01
+ 6.485000000000e-03 9.749886831188e-01
+ 6.486000000000e-03 8.404806072977e-01
+ 6.487000000000e-03 5.163911648745e-01
+ 6.488000000000e-03 1.831750369060e-01
+ 6.489000000000e-03 2.636869025721e-02
+ 6.490000000000e-03 1.332827113534e-01
+ 6.491000000000e-03 4.443868191920e-01
+ 6.492000000000e-03 7.864566343064e-01
+ 6.493000000000e-03 9.690259109465e-01
+ 6.494000000000e-03 8.904391297578e-01
+ 6.495000000000e-03 5.944538177633e-01
+ 6.496000000000e-03 2.458761305539e-01
+ 6.497000000000e-03 3.879593078792e-02
+ 6.498000000000e-03 8.851654683815e-02
+ 6.499000000000e-03 3.673532820228e-01
+ 6.500000000000e-03 7.200483971868e-01
+ 6.501000000000e-03 9.502194244494e-01
+ 6.502000000000e-03 9.297059430249e-01
+ 6.503000000000e-03 6.699299656762e-01
+ 6.504000000000e-03 3.155361028185e-01
+ 6.505000000000e-03 6.385269385076e-02
+ 6.506000000000e-03 5.501836517526e-02
+ 6.507000000000e-03 2.939521167803e-01
+ 6.508000000000e-03 6.476143975560e-01
+ 6.509000000000e-03 9.190842167961e-01
+ 6.510000000000e-03 9.572057723212e-01
+ 6.511000000000e-03 7.407527844594e-01
+ 6.512000000000e-03 3.902473985672e-01
+ 6.513000000000e-03 1.008528299191e-01
+ 6.514000000000e-03 3.370547405640e-02
+ 6.515000000000e-03 2.261933266982e-01
+ 6.516000000000e-03 5.711381539715e-01
+ 6.517000000000e-03 8.764728884569e-01
+ 6.518000000000e-03 9.721855676698e-01
+ 6.519000000000e-03 8.049828758160e-01
+ 6.520000000000e-03 4.679641382075e-01
+ 6.521000000000e-03 1.487831344632e-01
+ 6.522000000000e-03 2.516150154661e-02
+ 6.523000000000e-03 1.659324053050e-01
+ 6.524000000000e-03 4.927138770143e-01
+ 6.525000000000e-03 8.235522997607e-01
+ 6.526000000000e-03 9.742351252685e-01
+ 6.527000000000e-03 8.608613754175e-01
+ 6.528000000000e-03 5.465581416569e-01
+ 6.529000000000e-03 2.063310933454e-01
+ 6.530000000000e-03 2.962041412755e-02
+ 6.531000000000e-03 1.148195259524e-01
+ 6.532000000000e-03 4.144891218319e-01
+ 6.533000000000e-03 7.617716178150e-01
+ 6.534000000000e-03 9.632983204303e-01
+ 6.535000000000e-03 9.068581172981e-01
+ 6.536000000000e-03 6.238772060102e-01
+ 6.537000000000e-03 2.719208244520e-01
+ 6.538000000000e-03 4.696010980429e-02
+ 6.539000000000e-03 7.425435378766e-02
+ 6.540000000000e-03 3.386059799063e-01
+ 6.541000000000e-03 6.928226327991e-01
+ 6.542000000000e-03 9.396746444922e-01
+ 6.543000000000e-03 9.417135356242e-01
+ 6.544000000000e-03 6.978040410469e-01
+ 6.545000000000e-03 3.437562313429e-01
+ 6.546000000000e-03 7.670576172263e-02
+ 6.547000000000e-03 4.534771759607e-02
+ 6.548000000000e-03 2.671424204379e-01
+ 6.549000000000e-03 6.185934303083e-01
+ 6.550000000000e-03 9.040110036008e-01
+ 6.551000000000e-03 9.644731563991e-01
+ 6.552000000000e-03 7.663142486939e-01
+ 6.553000000000e-03 4.198701872065e-01
+ 6.554000000000e-03 1.180428207360e-01
+ 6.555000000000e-03 2.889119108070e-02
+ 6.556000000000e-03 2.020553876393e-01
+ 6.557000000000e-03 5.411166883870e-01
+ 6.558000000000e-03 8.572840039631e-01
+ 6.559000000000e-03 9.745137345943e-01
+ 6.560000000000e-03 8.275317587503e-01
+ 6.561000000000e-03 4.981784022797e-01
+ 6.562000000000e-03 1.698393208597e-01
+ 6.563000000000e-03 2.533541656324e-02
+ 6.564000000000e-03 1.451272121592e-01
+ 6.565000000000e-03 4.625140150676e-01
+ 6.566000000000e-03 8.007732086485e-01
+ 6.567000000000e-03 9.715603209692e-01
+ 6.568000000000e-03 8.797802028265e-01
+ 6.569000000000e-03 5.765364996306e-01
+ 6.570000000000e-03 2.306768768084e-01
+ 6.571000000000e-03 3.477776468151e-02
+ 6.572000000000e-03 9.791680408209e-02
+ 6.573000000000e-03 3.849378506691e-01
+ 6.574000000000e-03 7.360260982857e-01
+ 6.575000000000e-03 9.556937912281e-01
+ 6.576000000000e-03 9.216288196916e-01
+ 6.577000000000e-03 6.527987363611e-01
+ 6.578000000000e-03 2.988895247822e-01
+ 6.579000000000e-03 5.695966801107e-02
+ 6.580000000000e-03 6.171696404137e-02
+ 6.581000000000e-03 3.105125257898e-01
+ 6.582000000000e-03 6.648156951513e-01
+ 6.583000000000e-03 9.273486313353e-01
+ 6.584000000000e-03 9.519316349605e-01
+ 6.585000000000e-03 7.248767622125e-01
+ 6.586000000000e-03 3.726093428951e-01
+ 6.587000000000e-03 9.127370162507e-02
+ 6.588000000000e-03 3.751898141582e-02
+ 6.589000000000e-03 2.412760890503e-01
+ 6.590000000000e-03 5.890920110765e-01
+ 6.591000000000e-03 8.873010396370e-01
+ 6.592000000000e-03 9.698588422333e-01
+ 6.593000000000e-03 7.907968065439e-01
+ 6.594000000000e-03 4.498176019864e-01
+ 6.595000000000e-03 1.367802167011e-01
+ 6.596000000000e-03 2.598548905565e-02
+ 6.597000000000e-03 1.791244975700e-01
+ 6.598000000000e-03 5.109286486974e-01
+ 6.599000000000e-03 8.366476715949e-01
+ 6.600000000000e-03 9.749195263530e-01
+ 6.601000000000e-03 8.487537276817e-01
+ 6.602000000000e-03 5.284000461050e-01
+ 6.603000000000e-03 1.922330716807e-01
+ 6.604000000000e-03 2.743231787251e-02
+ 6.605000000000e-03 1.257596984411e-01
+ 6.606000000000e-03 4.324660183278e-01
+ 6.607000000000e-03 7.767756091883e-01
+ 6.608000000000e-03 9.669751065297e-01
+ 6.609000000000e-03 8.971604445695e-01
+ 6.610000000000e-03 6.062047888846e-01
+ 6.611000000000e-03 2.561137563681e-01
+ 6.612000000000e-03 4.181984818747e-02
+ 6.613000000000e-03 8.264302294455e-02
+ 6.614000000000e-03 3.558527253782e-01
+ 6.615000000000e-03 7.093243773294e-01
+ 6.616000000000e-03 9.462431312109e-01
+ 6.617000000000e-03 9.346913970866e-01
+ 6.618000000000e-03 6.811012403807e-01
+ 6.619000000000e-03 3.266729745174e-01
+ 6.620000000000e-03 6.875409466843e-02
+ 6.621000000000e-03 5.095516973593e-02
+ 6.622000000000e-03 2.831867333609e-01
+ 6.623000000000e-03 6.361410474335e-01
+ 6.624000000000e-03 9.132913207765e-01
+ 6.625000000000e-03 9.603188449285e-01
+ 6.626000000000e-03 7.510384507328e-01
+ 6.627000000000e-03 4.019785462227e-01
+ 6.628000000000e-03 1.074974951485e-01
+ 6.629000000000e-03 3.156387282519e-02
+ 6.630000000000e-03 2.164579136702e-01
+ 6.631000000000e-03 5.592296575722e-01
+ 6.632000000000e-03 8.690220211946e-01
+ 6.633000000000e-03 9.733410110481e-01
+ 6.634000000000e-03 8.141012729743e-01
+ 6.635000000000e-03 4.799683183542e-01
+ 6.636000000000e-03 1.569891078839e-01
+ 6.637000000000e-03 2.500013971513e-02
+ 6.638000000000e-03 1.574935553253e-01
+ 6.639000000000e-03 4.806963342875e-01
+ 6.640000000000e-03 8.146474943550e-01
+ 6.641000000000e-03 9.734012989808e-01
+ 6.642000000000e-03 8.685628070459e-01
+ 6.643000000000e-03 5.585066341599e-01
+ 6.644000000000e-03 2.158736641771e-01
+ 6.645000000000e-03 3.144371039680e-02
+ 6.646000000000e-03 1.079083268479e-01
+ 6.647000000000e-03 4.026916188308e-01
+ 6.648000000000e-03 7.516567217256e-01
+ 6.649000000000e-03 9.604980578136e-01
+ 6.650000000000e-03 9.129316888909e-01
+ 6.651000000000e-03 6.354428156742e-01
+ 6.652000000000e-03 2.825386807906e-01
+ 6.653000000000e-03 5.071813538373e-02
+ 6.654000000000e-03 6.906006048999e-02
+ 6.655000000000e-03 3.273515771577e-01
+ 6.656000000000e-03 6.817746303733e-01
+ 6.657000000000e-03 9.349846273934e-01
+ 6.658000000000e-03 9.459929296778e-01
+ 6.659000000000e-03 7.086700574667e-01
+ 6.660000000000e-03 3.551586158759e-01
+ 6.661000000000e-03 8.229560757114e-02
+ 6.662000000000e-03 4.201256962285e-02
+ 6.663000000000e-03 2.567393063183e-01
+ 6.664000000000e-03 6.069148578956e-01
+ 6.665000000000e-03 8.975596625362e-01
+ 6.666000000000e-03 9.668411868194e-01
+ 6.667000000000e-03 7.761831189896e-01
+ 6.668000000000e-03 4.317448592539e-01
+ 6.669000000000e-03 1.253114156015e-01
+ 6.670000000000e-03 2.750651747541e-02
+ 6.671000000000e-03 1.927884390027e-01
+ 6.672000000000e-03 5.291273497432e-01
+ 6.673000000000e-03 8.492480012012e-01
+ 6.674000000000e-03 9.749055556968e-01
+ 6.675000000000e-03 8.361332356967e-01
+ 6.676000000000e-03 5.102001881313e-01
+ 6.677000000000e-03 1.785876229543e-01
+ 6.678000000000e-03 2.593913495857e-02
+ 6.679000000000e-03 1.372501933244e-01
+ 6.680000000000e-03 4.505422239103e-01
+ 6.681000000000e-03 7.913726005262e-01
+ 6.682000000000e-03 9.699652032008e-01
+ 6.683000000000e-03 8.868787452518e-01
+ 6.684000000000e-03 5.883761970402e-01
+ 6.685000000000e-03 2.406653243286e-01
+ 6.686000000000e-03 3.735334297025e-02
+ 6.687000000000e-03 9.164541780071e-02
+ 6.688000000000e-03 3.733114401989e-01
+ 6.689000000000e-03 7.255183092273e-01
+ 6.690000000000e-03 9.521554149837e-01
+ 6.691000000000e-03 9.270300424904e-01
+ 6.692000000000e-03 6.641321293581e-01
+ 6.693000000000e-03 3.098445960244e-01
+ 6.694000000000e-03 6.143657705847e-02
+ 6.695000000000e-03 5.722294473585e-02
+ 6.696000000000e-03 2.995498713699e-01
+ 6.697000000000e-03 6.534884684097e-01
+ 6.698000000000e-03 9.219638908219e-01
+ 6.699000000000e-03 9.554876320984e-01
+ 6.700000000000e-03 7.353934993675e-01
+ 6.701000000000e-03 3.842310463187e-01
+ 6.702000000000e-03 9.752934662438e-02
+ 6.703000000000e-03 3.492539243680e-02
+ 6.704000000000e-03 2.312773898775e-01
+ 6.705000000000e-03 5.772555292246e-01
+ 6.706000000000e-03 8.802173895413e-01
+ 6.707000000000e-03 9.714722369763e-01
+ 6.708000000000e-03 8.002088995717e-01
+ 6.709000000000e-03 4.617876911252e-01
+ 6.710000000000e-03 1.446432942863e-01
+ 6.711000000000e-03 2.536335273930e-02
+ 6.712000000000e-03 1.703635560774e-01
+ 6.713000000000e-03 4.989070396526e-01
+ 6.714000000000e-03 8.280590892136e-01
+ 6.715000000000e-03 9.745461378132e-01
+ 6.716000000000e-03 8.568034376574e-01
+ 6.717000000000e-03 5.403907343661e-01
+ 6.718000000000e-03 2.014882608642e-01
+ 6.719000000000e-03 2.879867067872e-02
+ 6.720000000000e-03 1.184764225464e-01
+ 6.721000000000e-03 4.205884794942e-01
+ 6.722000000000e-03 7.669172825908e-01
+ 6.723000000000e-03 9.646251595063e-01
+ 6.724000000000e-03 9.036273398005e-01
+ 6.725000000000e-03 6.178877255923e-01
+ 6.726000000000e-03 2.665076148499e-01
+ 6.727000000000e-03 4.513727417674e-02
+ 6.728000000000e-03 7.703685645865e-02
+ 6.729000000000e-03 3.444445089691e-01
+ 6.730000000000e-03 6.984662650144e-01
+ 6.731000000000e-03 9.419809761961e-01
+ 6.732000000000e-03 9.393983893720e-01
+ 6.733000000000e-03 6.921565022691e-01
+ 6.734000000000e-03 3.379208788981e-01
+ 6.735000000000e-03 7.393175009266e-02
+ 6.736000000000e-03 4.717963083167e-02
+ 6.737000000000e-03 2.725602397561e-01
+ 6.738000000000e-03 6.245804858361e-01
+ 6.739000000000e-03 9.072336717942e-01
+ 6.740000000000e-03 9.631370389069e-01
+ 6.741000000000e-03 7.611633026601e-01
+ 6.742000000000e-03 4.137724860763e-01
+ 6.743000000000e-03 1.143935960985e-01
+ 6.744000000000e-03 2.972235012535e-02
+ 6.745000000000e-03 2.069041367030e-01
+ 6.746000000000e-03 5.472832188631e-01
+ 6.747000000000e-03 8.613347597264e-01
+ 6.748000000000e-03 9.741932338436e-01
+ 6.749000000000e-03 8.230184579646e-01
+ 6.750000000000e-03 4.919853307255e-01
+ 6.751000000000e-03 1.654148128723e-01
+ 6.752000000000e-03 2.514306111931e-02
+ 6.753000000000e-03 1.492741137665e-01
+ 6.754000000000e-03 4.686911574209e-01
+ 6.755000000000e-03 8.055411268739e-01
+ 6.756000000000e-03 9.722642134903e-01
+ 6.757000000000e-03 8.760281386394e-01
+ 6.758000000000e-03 5.704176475189e-01
+ 6.759000000000e-03 2.255982453377e-01
+ 6.760000000000e-03 3.356716217307e-02
+ 6.761000000000e-03 1.012483002865e-01
+ 6.762000000000e-03 3.909564512351e-01
+ 6.763000000000e-03 7.413806152279e-01
+ 6.764000000000e-03 9.574028017649e-01
+ 6.765000000000e-03 9.187407378996e-01
+ 6.766000000000e-03 6.469216611490e-01
+ 6.767000000000e-03 2.932958420840e-01
+ 6.768000000000e-03 5.476396934161e-02
+ 6.769000000000e-03 6.414182579826e-02
+ 6.770000000000e-03 3.162077723804e-01
+ 6.771000000000e-03 6.706101837601e-01
+ 6.772000000000e-03 9.300159606760e-01
+ 6.773000000000e-03 9.499866222334e-01
+ 6.774000000000e-03 7.194024005840e-01
+ 6.775000000000e-03 3.666537852893e-01
+ 6.776000000000e-03 8.815303338022e-02
+ 6.777000000000e-03 3.897080678270e-02
+ 6.778000000000e-03 2.464920241413e-01
+ 6.779000000000e-03 5.951677962020e-01
+ 6.780000000000e-03 8.908536461533e-01
+ 6.781000000000e-03 9.689101604216e-01
+ 6.782000000000e-03 7.858750673532e-01
+ 6.783000000000e-03 4.436632553039e-01
+ 6.784000000000e-03 1.328200346527e-01
+ 6.785000000000e-03 2.642452152903e-02
+ 6.786000000000e-03 1.837182890085e-01
+ 6.787000000000e-03 5.171193522219e-01
+ 6.788000000000e-03 8.409882714011e-01
+ 6.789000000000e-03 9.749931539747e-01
+ 6.790000000000e-03 8.445193868773e-01
+ 6.791000000000e-03 5.222154397783e-01
+ 6.792000000000e-03 1.875418206843e-01
+ 6.793000000000e-03 2.684653507253e-02
+ 6.794000000000e-03 1.296055507362e-01
+ 6.795000000000e-03 4.386021152304e-01
+ 6.796000000000e-03 7.817853401438e-01
+ 6.797000000000e-03 9.680690273805e-01
+ 6.798000000000e-03 8.937294545170e-01
+ 6.799000000000e-03 6.001592809705e-01
+ 6.800000000000e-03 2.508199007279e-01
+ 6.801000000000e-03 4.022529107629e-02
+ 6.802000000000e-03 8.563562202505e-02
+ 6.803000000000e-03 3.617661859738e-01
+ 6.804000000000e-03 7.148660539354e-01
+ 6.805000000000e-03 9.483273895748e-01
+ 6.806000000000e-03 9.321577113498e-01
+ 6.807000000000e-03 6.753603798921e-01
+ 6.808000000000e-03 3.209214801475e-01
+ 6.809000000000e-03 6.619442828807e-02
+ 6.810000000000e-03 5.301256685072e-02
+ 6.811000000000e-03 2.887156245956e-01
+ 6.812000000000e-03 6.420629174960e-01
+ 6.813000000000e-03 9.163088417278e-01
+ 6.814000000000e-03 9.587518454653e-01
+ 6.815000000000e-03 7.457594442768e-01
+ 6.816000000000e-03 3.959269109259e-01
+ 6.817000000000e-03 1.040428129051e-01
+ 6.818000000000e-03 3.262972861154e-02
+ 6.819000000000e-03 2.214508334609e-01
+ 6.820000000000e-03 5.653695577531e-01
+ 6.821000000000e-03 8.728901735265e-01
+ 6.822000000000e-03 9.727836082668e-01
+ 6.823000000000e-03 8.094286798367e-01
+ 6.824000000000e-03 4.737822589344e-01
+ 6.825000000000e-03 1.527340121243e-01
+ 6.826000000000e-03 2.504526698564e-02
+ 6.827000000000e-03 1.618137785279e-01
+ 6.828000000000e-03 4.868861307549e-01
+ 6.829000000000e-03 8.192603533367e-01
+ 6.830000000000e-03 9.738687566908e-01
+ 6.831000000000e-03 8.646245806091e-01
+ 6.832000000000e-03 5.523555484652e-01
+ 6.833000000000e-03 2.109346756155e-01
+ 6.834000000000e-03 3.046687339500e-02
+ 6.835000000000e-03 1.114375493104e-01
+ 6.836000000000e-03 4.087618114011e-01
+ 6.837000000000e-03 7.568879697232e-01
+ 6.838000000000e-03 9.619775752439e-01
+ 6.839000000000e-03 9.098356727810e-01
+ 6.840000000000e-03 6.294951438390e-01
+ 6.841000000000e-03 2.770510477300e-01
+ 6.842000000000e-03 4.874608362422e-02
+ 6.843000000000e-03 7.170163867115e-02
+ 6.844000000000e-03 3.331359408591e-01
+ 6.845000000000e-03 6.874810159094e-01
+ 6.846000000000e-03 9.374356897262e-01
+ 6.847000000000e-03 9.438239045984e-01
+ 6.848000000000e-03 7.030886693797e-01
+ 6.849000000000e-03 3.492726105923e-01
+ 6.850000000000e-03 7.938234333549e-02
+ 6.851000000000e-03 4.369416705914e-02
+ 6.852000000000e-03 2.620794432593e-01
+ 6.853000000000e-03 6.129401184187e-01
+ 6.854000000000e-03 9.009151503575e-01
+ 6.855000000000e-03 9.656585489312e-01
+ 6.856000000000e-03 7.711208542963e-01
+ 6.857000000000e-03 4.256216629713e-01
+ 6.858000000000e-03 1.215367151513e-01
+ 6.859000000000e-03 2.818208562985e-02
+ 6.860000000000e-03 1.975381159124e-01
+ 6.861000000000e-03 5.353064906912e-01
+ 6.862000000000e-03 8.534160284854e-01
+ 6.863000000000e-03 9.747416901256e-01
+ 6.864000000000e-03 8.317287184697e-01
+ 6.865000000000e-03 5.040074772657e-01
+ 6.866000000000e-03 1.740548519521e-01
+ 6.867000000000e-03 2.559017420420e-02
+ 6.868000000000e-03 1.412793459740e-01
+ 6.869000000000e-03 4.567060368889e-01
+ 6.870000000000e-03 7.962390308242e-01
+ 6.871000000000e-03 9.708245972097e-01
+ 6.872000000000e-03 8.832525879334e-01
+ 6.873000000000e-03 5.822835515816e-01
+ 6.874000000000e-03 2.354986072945e-01
+ 6.875000000000e-03 3.598940918053e-02
+ 6.876000000000e-03 9.484371265771e-02
+ 6.877000000000e-03 3.792911365522e-01
+ 6.878000000000e-03 7.309498811589e-01
+ 6.879000000000e-03 9.540145350941e-01
+ 6.880000000000e-03 9.242815430680e-01
+ 6.881000000000e-03 6.583063891248e-01
+ 6.882000000000e-03 3.041854173321e-01
+ 6.883000000000e-03 5.909501993085e-02
+ 6.884000000000e-03 5.950280031592e-02
+ 6.885000000000e-03 3.051817042557e-01
+ 6.886000000000e-03 6.593364448648e-01
+ 6.887000000000e-03 9.247718272504e-01
+ 6.888000000000e-03 9.536920549454e-01
+ 6.889000000000e-03 7.299941952970e-01
+ 6.890000000000e-03 3.782343758177e-01
+ 6.891000000000e-03 9.427428690416e-02
+ 6.892000000000e-03 3.622437761814e-02
+ 6.893000000000e-03 2.364071382798e-01
+ 6.894000000000e-03 5.833597703541e-01
+ 6.895000000000e-03 8.838972503030e-01
+ 6.896000000000e-03 9.706787518283e-01
+ 6.897000000000e-03 7.953838851565e-01
+ 6.898000000000e-03 4.556177404738e-01
+ 6.899000000000e-03 1.405638678954e-01
+ 6.900000000000e-03 2.564589636437e-02
+ 6.901000000000e-03 1.748507479635e-01
+ 6.902000000000e-03 5.051003881039e-01
+ 6.903000000000e-03 8.325101057167e-01
+ 6.904000000000e-03 9.747764733130e-01
+ 6.905000000000e-03 8.526848401536e-01
+ 6.906000000000e-03 5.342164602925e-01
+ 6.907000000000e-03 1.966961780219e-01
+ 6.908000000000e-03 2.805703562774e-02
+ 6.909000000000e-03 1.221981815265e-01
+ 6.910000000000e-03 4.267013378186e-01
+ 6.911000000000e-03 7.720175690657e-01
+ 6.912000000000e-03 9.658730081915e-01
+ 6.913000000000e-03 9.003279420817e-01
+ 6.914000000000e-03 6.118782032177e-01
+ 6.915000000000e-03 2.611341010202e-01
+ 6.916000000000e-03 4.339176923971e-02
+ 6.917000000000e-03 7.989126660867e-02
+ 6.918000000000e-03 3.503094838422e-01
+ 6.919000000000e-03 7.040761562075e-01
+ 6.920000000000e-03 9.442121672209e-01
+ 6.921000000000e-03 9.370085415032e-01
+ 6.922000000000e-03 6.864762951850e-01
+ 6.923000000000e-03 3.321130813394e-01
+ 6.924000000000e-03 7.123017383749e-02
+ 6.925000000000e-03 4.908852753920e-02
+ 6.926000000000e-03 2.780167258472e-01
+ 6.927000000000e-03 6.305463615787e-01
+ 6.928000000000e-03 9.103871066575e-01
+ 6.929000000000e-03 9.617221840176e-01
+ 6.930000000000e-03 7.559679565527e-01
+ 6.931000000000e-03 4.076894443870e-01
+ 6.932000000000e-03 1.108099279638e-01
+ 6.933000000000e-03 3.063346053428e-02
+ 6.934000000000e-03 2.118027146585e-01
+ 6.935000000000e-03 5.534417107734e-01
+ 6.936000000000e-03 8.653240853813e-01
+ 6.937000000000e-03 9.737921160448e-01
+ 6.938000000000e-03 8.184502411807e-01
+ 6.939000000000e-03 4.857936217356e-01
+ 6.940000000000e-03 1.610471873293e-01
+ 6.941000000000e-03 2.503143555927e-02
+ 6.942000000000e-03 1.534806418797e-01
+ 6.943000000000e-03 4.748736225551e-01
+ 6.944000000000e-03 8.102571004029e-01
+ 6.945000000000e-03 9.728878169137e-01
+ 6.946000000000e-03 8.722121463397e-01
+ 6.947000000000e-03 5.642868237841e-01
+ 6.948000000000e-03 2.205662645945e-01
+ 6.949000000000e-03 3.243585737667e-02
+ 6.950000000000e-03 1.046475878101e-01
+ 6.951000000000e-03 3.969935901694e-01
+ 6.952000000000e-03 7.466940953284e-01
+ 6.953000000000e-03 9.590340497758e-01
+ 6.954000000000e-03 9.157814664746e-01
+ 6.955000000000e-03 6.410196079532e-01
+ 6.956000000000e-03 2.877373009232e-01
+ 6.957000000000e-03 5.264396473954e-02
+ 6.958000000000e-03 6.664078730375e-02
+ 6.959000000000e-03 3.219342652770e-01
+ 6.960000000000e-03 6.763756671267e-01
+ 6.961000000000e-03 9.326101834959e-01
+ 6.962000000000e-03 9.479651077965e-01
+ 6.963000000000e-03 7.138907386048e-01
+ 6.964000000000e-03 3.607208977207e-01
+ 6.965000000000e-03 8.510238276608e-02
+ 6.966000000000e-03 4.050101119437e-02
+ 6.967000000000e-03 2.517510578327e-01
+ 6.968000000000e-03 6.012274019596e-01
+ 6.969000000000e-03 8.943398040892e-01
+ 6.970000000000e-03 9.678817597309e-01
+ 6.971000000000e-03 7.809047268696e-01
+ 6.972000000000e-03 4.375184863663e-01
+ 6.973000000000e-03 1.289222764496e-01
+ 6.974000000000e-03 2.694406602667e-02
+ 6.975000000000e-03 1.883658511382e-01
+ 6.976000000000e-03 5.233071453053e-01
+ 6.977000000000e-03 8.452709001824e-01
+ 6.978000000000e-03 9.749860285547e-01
+ 6.979000000000e-03 8.402264747271e-01
+ 6.980000000000e-03 5.160270566297e-01
+ 6.981000000000e-03 1.829036903448e-01
+ 6.982000000000e-03 2.634119255074e-02
+ 6.983000000000e-03 1.335143733674e-01
+ 6.984000000000e-03 4.447486503165e-01
+ 6.985000000000e-03 7.867471650963e-01
+ 6.986000000000e-03 9.690833723523e-01
+ 6.987000000000e-03 8.902315269710e-01
+ 6.988000000000e-03 5.940967450914e-01
+ 6.989000000000e-03 2.455684079112e-01
+ 6.990000000000e-03 3.870889973647e-02
+ 6.991000000000e-03 8.869866671849e-02
+ 6.992000000000e-03 3.677031475417e-01
+ 6.993000000000e-03 7.203712014103e-01
+ 6.994000000000e-03 9.503354283129e-01
+ 6.995000000000e-03 9.295505549761e-01
+ 6.996000000000e-03 6.695897065863e-01
+ 6.997000000000e-03 3.152004307114e-01
+ 6.998000000000e-03 6.370851269571e-02
+ 6.999000000000e-03 5.514595578667e-02
+ 7.000000000000e-03 2.942804360443e-01
+ 7.001000000000e-03 6.479606356047e-01
+ 7.002000000000e-03 9.192555864900e-01
+ 7.003000000000e-03 9.571068541267e-01
+ 7.004000000000e-03 7.404386565390e-01
+ 7.005000000000e-03 3.898929689752e-01
+ 7.006000000000e-03 1.006554468891e-01
+ 7.007000000000e-03 3.377504148202e-02
+ 7.008000000000e-03 2.264911090760e-01
+ 7.009000000000e-03 5.714983445304e-01
+ 7.010000000000e-03 8.766949312276e-01
+ 7.011000000000e-03 9.721458280861e-01
+ 7.012000000000e-03 8.047034810842e-01
+ 7.013000000000e-03 4.676006567627e-01
+ 7.014000000000e-03 1.485379546572e-01
+ 7.015000000000e-03 2.517114076591e-02
+ 7.016000000000e-03 1.661914963826e-01
+ 7.017000000000e-03 4.930781566957e-01
+ 7.018000000000e-03 8.238189352313e-01
+ 7.019000000000e-03 9.742556525166e-01
+ 7.020000000000e-03 8.606243647649e-01
+ 7.021000000000e-03 5.461955618633e-01
+ 7.022000000000e-03 2.060448307188e-01
+ 7.023000000000e-03 2.956986118192e-02
+ 7.024000000000e-03 1.150328308298e-01
+ 7.025000000000e-03 4.148475152713e-01
+ 7.026000000000e-03 7.620755444919e-01
+ 7.027000000000e-03 9.633785523961e-01
+ 7.028000000000e-03 9.066699809784e-01
+ 7.029000000000e-03 6.235254566828e-01
+ 7.030000000000e-03 2.716013179652e-01
+ 7.031000000000e-03 4.685074902578e-02
+ 7.032000000000e-03 7.441603136580e-02
+ 7.033000000000e-03 3.389486729275e-01
+ 7.034000000000e-03 6.931555280130e-01
+ 7.035000000000e-03 9.398123841189e-01
+ 7.036000000000e-03 9.415794255257e-01
+ 7.037000000000e-03 6.974727544208e-01
+ 7.038000000000e-03 3.434122302990e-01
+ 7.039000000000e-03 7.654058782572e-02
+ 7.040000000000e-03 4.545334052704e-02
+ 7.041000000000e-03 2.674600288015e-01
+ 7.042000000000e-03 6.189461781216e-01
+ 7.043000000000e-03 9.042024790540e-01
+ 7.044000000000e-03 9.643967449667e-01
+ 7.045000000000e-03 7.660124966577e-01
+ 7.046000000000e-03 4.195111116645e-01
+ 7.047000000000e-03 1.178263568104e-01
+ 7.048000000000e-03 2.893786700715e-02
+ 7.049000000000e-03 2.023392140206e-01
+ 7.050000000000e-03 5.414796292227e-01
+ 7.051000000000e-03 8.575239719154e-01
+ 7.052000000000e-03 9.744971142638e-01
+ 7.053000000000e-03 8.272678044231e-01
+ 7.054000000000e-03 4.978140850931e-01
+ 7.055000000000e-03 1.695774945112e-01
+ 7.056000000000e-03 2.532186732055e-02
+ 7.057000000000e-03 1.453694843109e-01
+ 7.058000000000e-03 4.628772102241e-01
+ 7.059000000000e-03 8.010550978645e-01
+ 7.060000000000e-03 9.716039468684e-01
+ 7.061000000000e-03 8.795612742822e-01
+ 7.062000000000e-03 5.761769171908e-01
+ 7.063000000000e-03 2.303768578390e-01
+ 7.064000000000e-03 3.470436129950e-02
+ 7.065000000000e-03 9.811088767095e-02
+ 7.066000000000e-03 3.852913544807e-01
+ 7.067000000000e-03 7.363421895655e-01
+ 7.068000000000e-03 9.557964687138e-01
+ 7.069000000000e-03 9.214609120269e-01
+ 7.070000000000e-03 6.524537354037e-01
+ 7.071000000000e-03 2.985595288526e-01
+ 7.072000000000e-03 5.682842055368e-02
+ 7.073000000000e-03 6.185754432000e-02
+ 7.074000000000e-03 3.108466579767e-01
+ 7.075000000000e-03 6.651573327135e-01
+ 7.076000000000e-03 9.275075487076e-01
+ 7.077000000000e-03 9.518193461260e-01
+ 7.078000000000e-03 7.245557901765e-01
+ 7.079000000000e-03 3.722584065509e-01
+ 7.080000000000e-03 9.108820414737e-02
+ 7.081000000000e-03 3.760220876154e-02
+ 7.082000000000e-03 2.415816998027e-01
+ 7.083000000000e-03 5.894498395842e-01
+ 7.084000000000e-03 8.875118451331e-01
+ 7.085000000000e-03 9.698052471251e-01
+ 7.086000000000e-03 7.905086528653e-01
+ 7.087000000000e-03 4.494553351990e-01
+ 7.088000000000e-03 1.365455488295e-01
+ 7.089000000000e-03 2.600908438685e-02
+ 7.090000000000e-03 1.793932181013e-01
+ 7.091000000000e-03 5.112928694444e-01
+ 7.092000000000e-03 8.369045925582e-01
+ 7.093000000000e-03 9.749260926088e-01
+ 7.094000000000e-03 8.485062831047e-01
+ 7.095000000000e-03 5.280363691181e-01
+ 7.096000000000e-03 1.919556595148e-01
+ 7.097000000000e-03 2.739563505923e-02
+ 7.098000000000e-03 1.259841701610e-01
+ 7.099000000000e-03 4.328266575640e-01
+ 7.100000000000e-03 7.770716101451e-01
+ 7.101000000000e-03 9.670416543405e-01
+ 7.102000000000e-03 8.969604850683e-01
+ 7.103000000000e-03 6.058496605580e-01
+ 7.104000000000e-03 2.558011965083e-01
+ 7.105000000000e-03 4.172389174474e-02
+ 7.106000000000e-03 8.281709896291e-02
+ 7.107000000000e-03 3.561999074284e-01
+ 7.108000000000e-03 7.096513526471e-01
+ 7.109000000000e-03 9.463678382444e-01
+ 7.110000000000e-03 9.345443983131e-01
+ 7.111000000000e-03 6.807643854798e-01
+ 7.112000000000e-03 3.263338260433e-01
+ 7.113000000000e-03 6.860149224899e-02
+ 7.114000000000e-03 5.107408318945e-02
+ 7.115000000000e-03 2.835109510606e-01
+ 7.116000000000e-03 6.364900432836e-01
+ 7.117000000000e-03 9.134707720795e-01
+ 7.118000000000e-03 9.602288322690e-01
+ 7.119000000000e-03 7.507290936263e-01
+ 7.120000000000e-03 4.016220963089e-01
+ 7.121000000000e-03 1.072924255869e-01
+ 7.122000000000e-03 3.162436741051e-02
+ 7.123000000000e-03 2.167502887038e-01
+ 7.124000000000e-03 5.595911171198e-01
+ 7.125000000000e-03 8.692513027075e-01
+ 7.126000000000e-03 9.733104493913e-01
+ 7.127000000000e-03 8.138278850367e-01
+ 7.128000000000e-03 4.796043279562e-01
+ 7.129000000000e-03 1.567371867654e-01
+ 7.130000000000e-03 2.500055886044e-02
+ 7.131000000000e-03 1.577460813521e-01
+ 7.132000000000e-03 4.810603593954e-01
+ 7.133000000000e-03 8.149203274775e-01
+ 7.134000000000e-03 9.734310252213e-01
+ 7.135000000000e-03 8.683328746797e-01
+ 7.136000000000e-03 5.581450707201e-01
+ 7.137000000000e-03 2.155817900606e-01
+ 7.138000000000e-03 3.138404262431e-02
+ 7.139000000000e-03 1.081140887441e-01
+ 7.140000000000e-03 4.030482411054e-01
+ 7.141000000000e-03 7.519656352484e-01
+ 7.142000000000e-03 9.605872579340e-01
+ 7.143000000000e-03 9.127515085191e-01
+ 7.144000000000e-03 6.350935801759e-01
+ 7.145000000000e-03 2.822148463006e-01
+ 7.146000000000e-03 5.060001462424e-02
+ 7.147000000000e-03 6.921342371227e-02
+ 7.148000000000e-03 3.276910309254e-01
+ 7.149000000000e-03 6.821111650687e-01
+ 7.150000000000e-03 9.351308587546e-01
+ 7.151000000000e-03 9.458674353252e-01
+ 7.152000000000e-03 7.083427133064e-01
+ 7.153000000000e-03 3.548116888322e-01
+ 7.154000000000e-03 8.212226842008e-02
+ 7.155000000000e-03 4.210933450234e-02
+ 7.156000000000e-03 2.570522960418e-01
+ 7.157000000000e-03 6.072697981626e-01
+ 7.158000000000e-03 8.977589207673e-01
+ 7.159000000000e-03 9.667738149985e-01
+ 7.160000000000e-03 7.758866300957e-01
+ 7.161000000000e-03 4.313843398396e-01
+ 7.162000000000e-03 1.250876047450e-01
+ 7.163000000000e-03 2.754403422147e-02
+ 7.164000000000e-03 1.930663938327e-01
+ 7.165000000000e-03 5.294909759673e-01
+ 7.166000000000e-03 8.494948298535e-01
+ 7.167000000000e-03 9.748981513045e-01
+ 7.168000000000e-03 8.358757210639e-01
+ 7.169000000000e-03 5.098359487399e-01
+ 7.170000000000e-03 1.783194691851e-01
+ 7.171000000000e-03 2.591637621992e-02
+ 7.172000000000e-03 1.374855017996e-01
+ 7.173000000000e-03 4.509045786213e-01
+ 7.174000000000e-03 7.916602404919e-01
+ 7.175000000000e-03 9.700179689976e-01
+ 7.176000000000e-03 8.866672566104e-01
+ 7.177000000000e-03 5.880182119329e-01
+ 7.178000000000e-03 2.403601707178e-01
+ 7.179000000000e-03 3.727093196786e-02
+ 7.180000000000e-03 9.183163628015e-02
+ 7.181000000000e-03 3.736626007463e-01
+ 7.182000000000e-03 7.258388838298e-01
+ 7.183000000000e-03 9.522669060411e-01
+ 7.184000000000e-03 9.268703712049e-01
+ 7.185000000000e-03 6.637902015289e-01
+ 7.186000000000e-03 3.095107988380e-01
+ 7.187000000000e-03 6.129677051885e-02
+ 7.188000000000e-03 5.735497384863e-02
+ 7.189000000000e-03 2.998802216407e-01
+ 7.190000000000e-03 6.538331990954e-01
+ 7.191000000000e-03 9.221310540908e-01
+ 7.192000000000e-03 9.553841505756e-01
+ 7.193000000000e-03 7.350769921013e-01
+ 7.194000000000e-03 3.838777461950e-01
+ 7.195000000000e-03 9.733597298304e-02
+ 7.196000000000e-03 3.499961672330e-02
+ 7.197000000000e-03 2.315778836246e-01
+ 7.198000000000e-03 5.776149759566e-01
+ 7.199000000000e-03 8.804356474550e-01
+ 7.200000000000e-03 9.714277789344e-01
+ 7.201000000000e-03 7.999264800422e-01
+ 7.202000000000e-03 4.614245627658e-01
+ 7.203000000000e-03 1.444016488493e-01
+ 7.204000000000e-03 2.537773965626e-02
+ 7.205000000000e-03 1.706259646381e-01
+ 7.206000000000e-03 4.992713594111e-01
+ 7.207000000000e-03 8.283224650399e-01
+ 7.208000000000e-03 9.745619206825e-01
+ 7.209000000000e-03 8.565628395862e-01
+ 7.210000000000e-03 5.400277216073e-01
+ 7.211000000000e-03 2.012049608034e-01
+ 7.212000000000e-03 2.875282625752e-02
+ 7.213000000000e-03 1.186935601764e-01
+ 7.214000000000e-03 4.209476958182e-01
+ 7.215000000000e-03 7.672185640977e-01
+ 7.216000000000e-03 9.647007510917e-01
+ 7.217000000000e-03 9.034351516785e-01
+ 7.218000000000e-03 6.175347691052e-01
+ 7.219000000000e-03 2.661904179982e-01
+ 7.220000000000e-03 4.503245381197e-02
+ 7.221000000000e-03 7.720277710295e-02
+ 7.222000000000e-03 3.447887851474e-01
+ 7.223000000000e-03 6.987972019666e-01
+ 7.224000000000e-03 9.421143065123e-01
+ 7.225000000000e-03 9.392598740409e-01
+ 7.226000000000e-03 6.918232673448e-01
+ 7.227000000000e-03 3.375784713134e-01
+ 7.228000000000e-03 7.377082416504e-02
+ 7.229000000000e-03 4.728979095151e-02
+ 7.230000000000e-03 2.728801481980e-01
+ 7.231000000000e-03 6.249320159216e-01
+ 7.232000000000e-03 9.074210897500e-01
+ 7.233000000000e-03 9.630559894440e-01
+ 7.234000000000e-03 7.608589145394e-01
+ 7.235000000000e-03 4.134142441809e-01
+ 7.236000000000e-03 1.141809713722e-01
+ 7.237000000000e-03 2.977373311768e-02
+ 7.238000000000e-03 2.071909170975e-01
+ 7.239000000000e-03 5.476457158500e-01
+ 7.240000000000e-03 8.615711331048e-01
+ 7.241000000000e-03 9.741718696915e-01
+ 7.242000000000e-03 8.227512519525e-01
+ 7.243000000000e-03 4.916210645458e-01
+ 7.244000000000e-03 1.651563118218e-01
+ 7.245000000000e-03 2.513425992214e-02
+ 7.246000000000e-03 1.495199129752e-01
+ 7.247000000000e-03 4.690546947626e-01
+ 7.248000000000e-03 8.058199828726e-01
+ 7.249000000000e-03 9.723031196807e-01
+ 7.250000000000e-03 8.758054318537e-01
+ 7.251000000000e-03 5.700573320495e-01
+ 7.252000000000e-03 2.253009467049e-01
+ 7.253000000000e-03 3.349841779658e-02
+ 7.254000000000e-03 1.014463873915e-01
+ 7.255000000000e-03 3.913110738945e-01
+ 7.256000000000e-03 7.416943177075e-01
+ 7.257000000000e-03 9.575009128983e-01
+ 7.258000000000e-03 9.185686288989e-01
+ 7.259000000000e-03 6.465751631974e-01
+ 7.260000000000e-03 2.929678870371e-01
+ 7.261000000000e-03 5.463716426860e-02
+ 7.262000000000e-03 6.428677642075e-02
+ 7.263000000000e-03 3.165437694409e-01
+ 7.264000000000e-03 6.709501423539e-01
+ 7.265000000000e-03 9.301705900963e-01
+ 7.266000000000e-03 9.498698240177e-01
+ 7.267000000000e-03 7.190792085840e-01
+ 7.268000000000e-03 3.663041544856e-01
+ 7.269000000000e-03 8.797164001607e-02
+ 7.270000000000e-03 3.905865162333e-02
+ 7.271000000000e-03 2.468001947242e-01
+ 7.272000000000e-03 5.955247015496e-01
+ 7.273000000000e-03 8.910605595185e-01
+ 7.274000000000e-03 9.688518713703e-01
+ 7.275000000000e-03 7.855840315313e-01
+ 7.276000000000e-03 4.433015229652e-01
+ 7.277000000000e-03 1.325890202383e-01
+ 7.278000000000e-03 2.645285506160e-02
+ 7.279000000000e-03 1.839901942306e-01
+ 7.280000000000e-03 5.174834308967e-01
+ 7.281000000000e-03 8.412418026358e-01
+ 7.282000000000e-03 9.749949702639e-01
+ 7.283000000000e-03 8.442684769021e-01
+ 7.284000000000e-03 5.218515115127e-01
+ 7.285000000000e-03 1.872675112729e-01
+ 7.286000000000e-03 2.681458141705e-02
+ 7.287000000000e-03 1.298337447980e-01
+ 7.288000000000e-03 4.389633973724e-01
+ 7.289000000000e-03 7.820785465976e-01
+ 7.290000000000e-03 9.681308992732e-01
+ 7.291000000000e-03 8.935255412576e-01
+ 7.292000000000e-03 5.998031225184e-01
+ 7.293000000000e-03 2.505098079553e-01
+ 7.294000000000e-03 4.013392524564e-02
+ 7.295000000000e-03 8.581385610396e-02
+ 7.296000000000e-03 3.621147783039e-01
+ 7.297000000000e-03 7.151909065010e-01
+ 7.298000000000e-03 9.484476227833e-01
+ 7.299000000000e-03 9.320063787281e-01
+ 7.300000000000e-03 6.750217442281e-01
+ 7.301000000000e-03 3.205840955339e-01
+ 7.302000000000e-03 6.604615222613e-02
+ 7.303000000000e-03 5.313596022011e-02
+ 7.304000000000e-03 2.890419813288e-01
+ 7.305000000000e-03 6.424105204727e-01
+ 7.306000000000e-03 9.164841438092e-01
+ 7.307000000000e-03 9.586572375440e-01
+ 7.308000000000e-03 7.454476045337e-01
+ 7.309000000000e-03 3.955714733460e-01
+ 7.310000000000e-03 1.038416869749e-01
+ 7.311000000000e-03 3.269490229118e-02
+ 7.312000000000e-03 2.217460177078e-01
+ 7.313000000000e-03 5.657303924490e-01
+ 7.314000000000e-03 8.731157440426e-01
+ 7.315000000000e-03 9.727483157709e-01
+ 7.316000000000e-03 8.091521753736e-01
+ 7.317000000000e-03 4.734185016217e-01
+ 7.318000000000e-03 1.524855439190e-01
+ 7.319000000000e-03 2.505043627215e-02
+ 7.320000000000e-03 1.620697070207e-01
+ 7.321000000000e-03 4.872503161424e-01
+ 7.322000000000e-03 8.195300153082e-01
+ 7.323000000000e-03 9.738937460631e-01
+ 7.324000000000e-03 8.643909831696e-01
+ 7.325000000000e-03 5.519934324788e-01
+ 7.326000000000e-03 2.106456691403e-01
+ 7.327000000000e-03 3.041189673371e-02
+ 7.328000000000e-03 1.116472137526e-01
+ 7.329000000000e-03 4.091193746989e-01
+ 7.330000000000e-03 7.571943387801e-01
+ 7.331000000000e-03 9.620621621804e-01
+ 7.332000000000e-03 9.096513791529e-01
+ 7.333000000000e-03 6.291445852938e-01
+ 7.334000000000e-03 2.767294170823e-01
+ 7.335000000000e-03 4.863246648520e-02
+ 7.336000000000e-03 7.185929765302e-02
+ 7.337000000000e-03 3.334770906237e-01
+ 7.338000000000e-03 6.878157024999e-01
+ 7.339000000000e-03 9.375775579146e-01
+ 7.340000000000e-03 9.436939614421e-01
+ 7.341000000000e-03 7.027592679016e-01
+ 7.342000000000e-03 3.489271632425e-01
+ 7.343000000000e-03 7.921319698845e-02
+ 7.344000000000e-03 4.379550327750e-02
+ 7.345000000000e-03 2.623948375115e-01
+ 7.346000000000e-03 6.132939575507e-01
+ 7.347000000000e-03 9.011104149069e-01
+ 7.348000000000e-03 9.655865145849e-01
+ 7.349000000000e-03 7.708216301521e-01
+ 7.350000000000e-03 4.252618585827e-01
+ 7.351000000000e-03 1.213166714669e-01
+ 7.352000000000e-03 2.822432411347e-02
+ 7.353000000000e-03 1.978191179574e-01
+ 7.354000000000e-03 5.356697929023e-01
+ 7.355000000000e-03 8.536593423091e-01
+ 7.356000000000e-03 9.747295371639e-01
+ 7.357000000000e-03 8.314678655544e-01
+ 7.358000000000e-03 5.036431686514e-01
+ 7.359000000000e-03 1.737899365638e-01
+ 7.360000000000e-03 2.557215830257e-02
+ 7.361000000000e-03 1.415182609061e-01
+ 7.362000000000e-03 4.570688535824e-01
+ 7.363000000000e-03 7.965237310647e-01
+ 7.364000000000e-03 9.708726584269e-01
+ 7.365000000000e-03 8.830372493929e-01
+ 7.366000000000e-03 5.819247148991e-01
+ 7.367000000000e-03 2.351960745942e-01
+ 7.368000000000e-03 3.591163223762e-02
+ 7.369000000000e-03 9.503399807769e-02
+ 7.370000000000e-03 3.796435324268e-01
+ 7.371000000000e-03 7.312681716391e-01
+ 7.372000000000e-03 9.541214943912e-01
+ 7.373000000000e-03 9.241176156910e-01
+ 7.374000000000e-03 6.579628506867e-01
+ 7.375000000000e-03 3.038535518156e-01
+ 7.376000000000e-03 5.895961177535e-02
+ 7.377000000000e-03 5.963924548412e-02
+ 7.378000000000e-03 3.055140293708e-01
+ 7.379000000000e-03 6.596796095806e-01
+ 7.380000000000e-03 9.249347556747e-01
+ 7.381000000000e-03 9.535840276872e-01
+ 7.382000000000e-03 7.296753624935e-01
+ 7.383000000000e-03 3.778822652262e-01
+ 7.384000000000e-03 9.408495552666e-02
+ 7.385000000000e-03 3.630324614682e-02
+ 7.386000000000e-03 2.367102923091e-01
+ 7.387000000000e-03 5.837184121492e-01
+ 7.388000000000e-03 8.841116862541e-01
+ 7.389000000000e-03 9.706295828864e-01
+ 7.390000000000e-03 7.950984888432e-01
+ 7.391000000000e-03 4.552550269348e-01
+ 7.392000000000e-03 1.403257979098e-01
+ 7.393000000000e-03 2.566502853307e-02
+ 7.394000000000e-03 1.751164293959e-01
+ 7.395000000000e-03 5.054646860019e-01
+ 7.396000000000e-03 8.327701771229e-01
+ 7.397000000000e-03 9.747875091202e-01
+ 7.398000000000e-03 8.524406955675e-01
+ 7.399000000000e-03 5.338530762842e-01
+ 7.400000000000e-03 1.964158886902e-01
+ 7.401000000000e-03 2.801590752492e-02
+ 7.402000000000e-03 1.224191149940e-01
+ 7.403000000000e-03 4.270613159563e-01
+ 7.404000000000e-03 7.723161541814e-01
+ 7.405000000000e-03 9.659439465453e-01
+ 7.406000000000e-03 9.001317348307e-01
+ 7.407000000000e-03 6.115240995759e-01
+ 7.408000000000e-03 2.608192677305e-01
+ 7.409000000000e-03 4.329150710931e-02
+ 7.410000000000e-03 8.006140211135e-02
+ 7.411000000000e-03 3.506552846484e-01
+ 7.412000000000e-03 7.044050786362e-01
+ 7.413000000000e-03 9.443410655593e-01
+ 7.414000000000e-03 9.368656444885e-01
+ 7.415000000000e-03 6.861411686155e-01
+ 7.416000000000e-03 3.317723254256e-01
+ 7.417000000000e-03 7.107352323818e-02
+ 7.418000000000e-03 4.920320611983e-02
+ 7.419000000000e-03 2.783388799797e-01
+ 7.420000000000e-03 6.308966141723e-01
+ 7.421000000000e-03 9.105704352535e-01
+ 7.422000000000e-03 9.616365103032e-01
+ 7.423000000000e-03 7.556609840961e-01
+ 7.424000000000e-03 4.073320970424e-01
+ 7.425000000000e-03 1.106011785852e-01
+ 7.426000000000e-03 3.068954185686e-02
+ 7.427000000000e-03 2.120924003110e-01
+ 7.428000000000e-03 5.538037022838e-01
+ 7.429000000000e-03 8.655568240005e-01
+ 7.430000000000e-03 9.737660117031e-01
+ 7.431000000000e-03 8.181798289115e-01
+ 7.432000000000e-03 4.854294684917e-01
+ 7.433000000000e-03 1.607920555239e-01
+ 7.434000000000e-03 2.502738390389e-02
+ 7.435000000000e-03 1.537299263576e-01
+ 7.436000000000e-03 4.752374402767e-01
+ 7.437000000000e-03 8.105328757757e-01
+ 7.438000000000e-03 9.729219967809e-01
+ 7.439000000000e-03 8.719856991746e-01
+ 7.440000000000e-03 5.639258365411e-01
+ 7.441000000000e-03 2.202717368416e-01
+ 7.442000000000e-03 3.237178369302e-02
+ 7.443000000000e-03 1.048496447547e-01
+ 7.444000000000e-03 3.973492713885e-01
+ 7.445000000000e-03 7.470053556758e-01
+ 7.446000000000e-03 9.591275778771e-01
+ 7.447000000000e-03 9.156051853984e-01
+ 7.448000000000e-03 6.406716719161e-01
+ 7.449000000000e-03 2.874114425138e-01
+ 7.450000000000e-03 5.252162360889e-02
+ 7.451000000000e-03 6.679008362739e-02
+ 7.452000000000e-03 3.222720700882e-01
+ 7.453000000000e-03 6.767138889560e-01
+ 7.454000000000e-03 9.327604986760e-01
+ 7.455000000000e-03 9.478438200562e-01
+ 7.456000000000e-03 7.135653815863e-01
+ 7.457000000000e-03 3.603726318977e-01
+ 7.458000000000e-03 8.492512435418e-02
+ 7.459000000000e-03 4.059345859540e-02
+ 7.460000000000e-03 2.520617358544e-01
+ 7.461000000000e-03 6.015833234700e-01
+ 7.462000000000e-03 8.945427901466e-01
+ 7.463000000000e-03 9.678187866462e-01
+ 7.464000000000e-03 7.806108583834e-01
+ 7.465000000000e-03 4.371573499744e-01
+ 7.466000000000e-03 1.286949547666e-01
+ 7.467000000000e-03 2.697713294366e-02
+ 7.468000000000e-03 1.886408948251e-01
+ 7.469000000000e-03 5.236710200114e-01
+ 7.470000000000e-03 8.455209985860e-01
+ 7.471000000000e-03 9.749830945686e-01
+ 7.472000000000e-03 8.399721420103e-01
+ 7.473000000000e-03 5.156629389565e-01
+ 7.474000000000e-03 1.826325303226e-01
+ 7.475000000000e-03 2.631397348555e-02
+ 7.476000000000e-03 1.337462509755e-01
+ 7.477000000000e-03 4.451105139436e-01
+ 7.478000000000e-03 7.870375272001e-01
+ 7.479000000000e-03 9.691405578084e-01
+ 7.480000000000e-03 8.900236946210e-01
+ 7.481000000000e-03 5.937396170648e-01
+ 7.482000000000e-03 2.452608349440e-01
+ 7.483000000000e-03 3.862214005069e-02
+ 7.484000000000e-03 8.888102855680e-02
+ 7.485000000000e-03 3.680530908875e-01
+ 7.486000000000e-03 7.206938759951e-01
+ 7.487000000000e-03 9.504511672558e-01
+ 7.488000000000e-03 9.293949142338e-01
+ 7.489000000000e-03 6.692493477307e-01
+ 7.490000000000e-03 3.148648673172e-01
+ 7.491000000000e-03 6.356458819970e-02
+ 7.492000000000e-03 5.527380809396e-02
+ 7.493000000000e-03 2.946088763278e-01
+ 7.494000000000e-03 6.483067866124e-01
+ 7.495000000000e-03 9.194267095470e-01
+ 7.496000000000e-03 9.570076670278e-01
+ 7.497000000000e-03 7.401243871756e-01
+ 7.498000000000e-03 3.895386041571e-01
+ 7.499000000000e-03 1.004582987835e-01
+ 7.500000000000e-03 3.384488317586e-02
+ 7.501000000000e-03 2.267890523528e-01
+ 7.502000000000e-03 5.718584930296e-01
+ 7.503000000000e-03 8.769167523979e-01
+ 7.504000000000e-03 9.721058107512e-01
+ 7.505000000000e-03 8.044239071036e-01
+ 7.506000000000e-03 4.672371943768e-01
+ 7.507000000000e-03 1.482929816066e-01
+ 7.508000000000e-03 2.518105931478e-02
+ 7.509000000000e-03 1.664507838312e-01
+ 7.510000000000e-03 4.934424404485e-01
+ 7.511000000000e-03 8.240853802076e-01
+ 7.512000000000e-03 9.742759007723e-01
+ 7.513000000000e-03 8.603871419664e-01
+ 7.514000000000e-03 5.458329548940e-01
+ 7.515000000000e-03 2.057587410185e-01
+ 7.516000000000e-03 2.951958497829e-02
+ 7.517000000000e-03 1.152463621735e-01
+ 7.518000000000e-03 4.152059588036e-01
+ 7.519000000000e-03 7.623793169966e-01
+ 7.520000000000e-03 9.634585117682e-01
+ 7.521000000000e-03 9.064816054252e-01
+ 7.522000000000e-03 6.231736346885e-01
+ 7.523000000000e-03 2.712819458395e-01
+ 7.524000000000e-03 4.674165482330e-02
+ 7.525000000000e-03 7.457795930364e-02
+ 7.526000000000e-03 3.392914606909e-01
+ 7.527000000000e-03 6.934883095988e-01
+ 7.528000000000e-03 9.399498650155e-01
+ 7.529000000000e-03 9.414450556574e-01
+ 7.530000000000e-03 6.971413516266e-01
+ 7.531000000000e-03 3.430683213725e-01
+ 7.532000000000e-03 7.637566303887e-02
+ 7.533000000000e-03 4.555923085623e-02
+ 7.534000000000e-03 2.677777739630e-01
+ 7.535000000000e-03 6.192988559628e-01
+ 7.536000000000e-03 9.043937167247e-01
+ 7.537000000000e-03 9.643200603417e-01
+ 7.538000000000e-03 7.657105881336e-01
+ 7.539000000000e-03 4.191520834712e-01
+ 7.540000000000e-03 1.176101177072e-01
+ 7.541000000000e-03 2.898482004731e-02
+ 7.542000000000e-03 2.026232155074e-01
+ 7.543000000000e-03 5.418425456566e-01
+ 7.544000000000e-03 8.577637295453e-01
+ 7.545000000000e-03 9.744802147988e-01
+ 7.546000000000e-03 8.270036575726e-01
+ 7.547000000000e-03 4.974497691924e-01
+ 7.548000000000e-03 1.693158625418e-01
+ 7.549000000000e-03 2.530859731878e-02
+ 7.550000000000e-03 1.456119650825e-01
+ 7.551000000000e-03 4.632404272189e-01
+ 7.552000000000e-03 8.013368099775e-01
+ 7.553000000000e-03 9.716472953351e-01
+ 7.554000000000e-03 8.793421224517e-01
+ 7.555000000000e-03 5.758172899380e-01
+ 7.556000000000e-03 2.300769974820e-01
+ 7.557000000000e-03 3.463123163892e-02
+ 7.558000000000e-03 9.830520768082e-02
+ 7.559000000000e-03 3.856449257725e-01
+ 7.560000000000e-03 7.366581418117e-01
+ 7.561000000000e-03 9.558988780663e-01
+ 7.562000000000e-03 9.212927564275e-01
+ 7.563000000000e-03 6.521086447617e-01
+ 7.564000000000e-03 2.982296514261e-01
+ 7.565000000000e-03 5.669743380271e-02
+ 7.566000000000e-03 6.199838234672e-02
+ 7.567000000000e-03 3.111809014383e-01
+ 7.568000000000e-03 6.654988731184e-01
+ 7.569000000000e-03 9.276662145879e-01
+ 7.570000000000e-03 9.517067914982e-01
+ 7.571000000000e-03 7.242346860406e-01
+ 7.572000000000e-03 3.719075453534e-01
+ 7.573000000000e-03 9.090294722150e-02
+ 7.574000000000e-03 3.768570812398e-02
+ 7.575000000000e-03 2.418874625751e-01
+ 7.576000000000e-03 5.898076154705e-01
+ 7.577000000000e-03 8.877224226657e-01
+ 7.578000000000e-03 9.697513756424e-01
+ 7.579000000000e-03 7.902203282879e-01
+ 7.580000000000e-03 4.490930981458e-01
+ 7.581000000000e-03 1.363110947688e-01
+ 7.582000000000e-03 2.603295855468e-02
+ 7.583000000000e-03 1.796621272374e-01
+ 7.584000000000e-03 5.116570835481e-01
+ 7.585000000000e-03 8.371613153292e-01
+ 7.586000000000e-03 9.749323794778e-01
+ 7.587000000000e-03 8.482586335104e-01
+ 7.588000000000e-03 5.276726756380e-01
+ 7.589000000000e-03 1.916784285634e-01
+ 7.590000000000e-03 2.735923026693e-02
+ 7.591000000000e-03 1.262088619047e-01
+ 7.592000000000e-03 4.331873363165e-01
+ 7.593000000000e-03 7.773674481078e-01
+ 7.594000000000e-03 9.671079274027e-01
+ 7.595000000000e-03 8.967602920454e-01
+ 7.596000000000e-03 6.054944699627e-01
+ 7.597000000000e-03 2.554887803050e-01
+ 7.598000000000e-03 4.162820489403e-02
+ 7.599000000000e-03 8.299142039942e-02
+ 7.600000000000e-03 3.565471740729e-01
+ 7.601000000000e-03 7.099782046323e-01
+ 7.602000000000e-03 9.464922826910e-01
+ 7.603000000000e-03 9.343971439086e-01
+ 7.604000000000e-03 6.804274242394e-01
+ 7.605000000000e-03 3.259947797320e-01
+ 7.606000000000e-03 6.844914360981e-02
+ 7.607000000000e-03 5.119326073438e-02
+ 7.608000000000e-03 2.838352961145e-01
+ 7.609000000000e-03 6.368389588397e-01
+ 7.610000000000e-03 9.136499801480e-01
+ 7.611000000000e-03 9.601385488684e-01
+ 7.612000000000e-03 7.504195890216e-01
+ 7.613000000000e-03 4.012657042683e-01
+ 7.614000000000e-03 1.070875870454e-01
+ 7.615000000000e-03 3.168513752909e-02
+ 7.616000000000e-03 2.170428303659e-01
+ 7.617000000000e-03 5.599525416123e-01
+ 7.618000000000e-03 8.694803669993e-01
+ 7.619000000000e-03 9.732796092982e-01
+ 7.620000000000e-03 8.135543124823e-01
+ 7.621000000000e-03 4.792403495565e-01
+ 7.622000000000e-03 1.564854675796e-01
+ 7.623000000000e-03 2.500125743568e-02
+ 7.624000000000e-03 1.579988087181e-01
+ 7.625000000000e-03 4.814243956451e-01
+ 7.626000000000e-03 8.151929753404e-01
+ 7.627000000000e-03 9.734604729546e-01
+ 7.628000000000e-03 8.681027256328e-01
+ 7.629000000000e-03 5.577834730750e-01
+ 7.630000000000e-03 2.152900832601e-01
+ 7.631000000000e-03 3.132465052650e-02
+ 7.632000000000e-03 1.083200811769e-01
+ 7.633000000000e-03 4.034049204148e-01
+ 7.634000000000e-03 7.522744005464e-01
+ 7.635000000000e-03 9.606761871026e-01
+ 7.636000000000e-03 9.125710853366e-01
+ 7.637000000000e-03 6.347442652050e-01
+ 7.638000000000e-03 2.818911399275e-01
+ 7.639000000000e-03 5.048215823490e-02
+ 7.640000000000e-03 6.936704035519e-02
+ 7.641000000000e-03 3.280305860571e-01
+ 7.642000000000e-03 6.824475926325e-01
+ 7.643000000000e-03 9.352768341394e-01
+ 7.644000000000e-03 9.457416786800e-01
+ 7.645000000000e-03 7.080152465826e-01
+ 7.646000000000e-03 3.544648471990e-01
+ 7.647000000000e-03 8.194917509614e-02
+ 7.648000000000e-03 4.220636874699e-02
+ 7.649000000000e-03 2.573654286851e-01
+ 7.650000000000e-03 6.076246753264e-01
+ 7.651000000000e-03 8.979579450071e-01
+ 7.652000000000e-03 9.667061685866e-01
+ 7.653000000000e-03 7.755899789048e-01
+ 7.654000000000e-03 4.310238607906e-01
+ 7.655000000000e-03 1.248640144398e-01
+ 7.656000000000e-03 2.758182890120e-02
+ 7.657000000000e-03 1.933445292238e-01
+ 7.658000000000e-03 5.298545848426e-01
+ 7.659000000000e-03 8.497414529069e-01
+ 7.660000000000e-03 9.748904675418e-01
+ 7.661000000000e-03 8.356180088440e-01
+ 7.662000000000e-03 5.094717035624e-01
+ 7.663000000000e-03 1.780515046524e-01
+ 7.664000000000e-03 2.589389637245e-02
+ 7.665000000000e-03 1.377210235330e-01
+ 7.666000000000e-03 4.512669622139e-01
+ 7.667000000000e-03 7.919477088813e-01
+ 7.668000000000e-03 9.700704582950e-01
+ 7.669000000000e-03 8.864555405031e-01
+ 7.670000000000e-03 5.876601750463e-01
+ 7.671000000000e-03 2.400551698461e-01
+ 7.672000000000e-03 3.718879317687e-02
+ 7.673000000000e-03 9.201809487452e-02
+ 7.674000000000e-03 3.740138356139e-01
+ 7.675000000000e-03 7.261593255764e-01
+ 7.676000000000e-03 9.523781310417e-01
+ 7.677000000000e-03 9.267104488022e-01
+ 7.678000000000e-03 6.634481773454e-01
+ 7.679000000000e-03 3.091771137118e-01
+ 7.680000000000e-03 6.115722205737e-02
+ 7.681000000000e-03 5.748726335793e-02
+ 7.682000000000e-03 3.002106896364e-01
+ 7.683000000000e-03 6.541778392858e-01
+ 7.684000000000e-03 9.222979690309e-01
+ 7.685000000000e-03 9.552804011621e-01
+ 7.686000000000e-03 7.347603465457e-01
+ 7.687000000000e-03 3.835245143835e-01
+ 7.688000000000e-03 9.714283621858e-02
+ 7.689000000000e-03 3.507411455772e-02
+ 7.690000000000e-03 2.318785352775e-01
+ 7.691000000000e-03 5.779743770297e-01
+ 7.692000000000e-03 8.806536815683e-01
+ 7.693000000000e-03 9.713830435637e-01
+ 7.694000000000e-03 7.996438840738e-01
+ 7.695000000000e-03 4.610614570993e-01
+ 7.696000000000e-03 1.441602126016e-01
+ 7.697000000000e-03 2.539240578127e-02
+ 7.698000000000e-03 1.708885669614e-01
+ 7.699000000000e-03 4.996356795982e-01
+ 7.700000000000e-03 8.285856477227e-01
+ 7.701000000000e-03 9.745774243792e-01
+ 7.702000000000e-03 8.563220317582e-01
+ 7.703000000000e-03 5.396646853012e-01
+ 7.704000000000e-03 2.009218365158e-01
+ 7.705000000000e-03 2.870725905884e-02
+ 7.706000000000e-03 1.189109221191e-01
+ 7.707000000000e-03 4.213069586457e-01
+ 7.708000000000e-03 7.675196884061e-01
+ 7.709000000000e-03 9.647760693057e-01
+ 7.710000000000e-03 9.032427262258e-01
+ 7.711000000000e-03 6.171817434747e-01
+ 7.712000000000e-03 2.658733586913e-01
+ 7.713000000000e-03 4.492790109313e-02
+ 7.714000000000e-03 7.736894646777e-02
+ 7.715000000000e-03 3.451331526328e-01
+ 7.716000000000e-03 6.991280219724e-01
+ 7.717000000000e-03 9.422473767443e-01
+ 7.718000000000e-03 9.391211003046e-01
+ 7.719000000000e-03 6.914899195763e-01
+ 7.720000000000e-03 3.372361592774e-01
+ 7.721000000000e-03 7.361014897706e-02
+ 7.722000000000e-03 4.740021738935e-02
+ 7.723000000000e-03 2.732001902486e-01
+ 7.724000000000e-03 6.252834725128e-01
+ 7.725000000000e-03 9.076082680302e-01
+ 7.726000000000e-03 9.629746675771e-01
+ 7.727000000000e-03 7.605543729622e-01
+ 7.728000000000e-03 4.130560532216e-01
+ 7.729000000000e-03 1.139685736133e-01
+ 7.730000000000e-03 2.982539273201e-02
+ 7.731000000000e-03 2.074778697441e-01
+ 7.732000000000e-03 5.480081848082e-01
+ 7.733000000000e-03 8.618072937802e-01
+ 7.734000000000e-03 9.741502265963e-01
+ 7.735000000000e-03 8.224838560742e-01
+ 7.736000000000e-03 4.912568032952e-01
+ 7.737000000000e-03 1.648980077509e-01
+ 7.738000000000e-03 2.512573807624e-02
+ 7.739000000000e-03 1.497659183622e-01
+ 7.740000000000e-03 4.694182503078e-01
+ 7.741000000000e-03 8.060986589646e-01
+ 7.742000000000e-03 9.723417480273e-01
+ 7.743000000000e-03 8.755825039911e-01
+ 7.744000000000e-03 5.696969753664e-01
+ 7.745000000000e-03 2.250038096705e-01
+ 7.746000000000e-03 3.342994785111e-02
+ 7.747000000000e-03 1.016447089551e-01
+ 7.748000000000e-03 3.916657604933e-01
+ 7.749000000000e-03 7.420078780052e-01
+ 7.750000000000e-03 9.575987548959e-01
+ 7.751000000000e-03 9.183962736653e-01
+ 7.752000000000e-03 6.462285790203e-01
+ 7.753000000000e-03 2.926400537823e-01
+ 7.754000000000e-03 5.451062119108e-02
+ 7.755000000000e-03 6.443198336245e-02
+ 7.756000000000e-03 3.168798744239e-01
+ 7.757000000000e-03 6.712900003821e-01
+ 7.758000000000e-03 9.303249664582e-01
+ 7.759000000000e-03 9.497527611553e-01
+ 7.760000000000e-03 7.187558877054e-01
+ 7.761000000000e-03 3.659546023316e-01
+ 7.762000000000e-03 8.779048903758e-02
+ 7.763000000000e-03 3.914676762388e-02
+ 7.764000000000e-03 2.471085142580e-01
+ 7.765000000000e-03 5.958815507025e-01
+ 7.766000000000e-03 8.912672428328e-01
+ 7.767000000000e-03 9.687933065056e-01
+ 7.768000000000e-03 7.852928277076e-01
+ 7.769000000000e-03 4.429398239808e-01
+ 7.770000000000e-03 1.323582219620e-01
+ 7.771000000000e-03 2.648146716976e-02
+ 7.772000000000e-03 1.842622853531e-01
+ 7.773000000000e-03 5.178474992865e-01
+ 7.774000000000e-03 8.414951331268e-01
+ 7.775000000000e-03 9.749965071258e-01
+ 7.776000000000e-03 8.440173644023e-01
+ 7.777000000000e-03 5.214875703920e-01
+ 7.778000000000e-03 1.869933858339e-01
+ 7.779000000000e-03 2.678290612444e-02
+ 7.780000000000e-03 1.300621566185e-01
+ 7.781000000000e-03 4.393247154211e-01
+ 7.782000000000e-03 7.823715871126e-01
+ 7.783000000000e-03 9.681924957767e-01
+ 7.784000000000e-03 8.933213964978e-01
+ 7.785000000000e-03 5.994469053556e-01
+ 7.786000000000e-03 2.501998619517e-01
+ 7.787000000000e-03 4.004282994224e-02
+ 7.788000000000e-03 8.599233383833e-02
+ 7.789000000000e-03 3.624634517483e-01
+ 7.790000000000e-03 7.155156324749e-01
+ 7.791000000000e-03 9.485675921814e-01
+ 7.792000000000e-03 9.318547919683e-01
+ 7.793000000000e-03 6.746830056034e-01
+ 7.794000000000e-03 3.202468164661e-01
+ 7.795000000000e-03 6.589813144806e-02
+ 7.796000000000e-03 5.325961646810e-02
+ 7.797000000000e-03 2.893684621627e-01
+ 7.798000000000e-03 6.427580396729e-01
+ 7.799000000000e-03 9.166592008837e-01
+ 7.800000000000e-03 9.585623598065e-01
+ 7.801000000000e-03 7.451356204001e-01
+ 7.802000000000e-03 3.952160971986e-01
+ 7.803000000000e-03 1.036407940943e-01
+ 7.804000000000e-03 3.276035087436e-02
+ 7.805000000000e-03 2.220413656445e-01
+ 7.806000000000e-03 5.660911884774e-01
+ 7.807000000000e-03 8.733410950645e-01
+ 7.808000000000e-03 9.727127451693e-01
+ 7.809000000000e-03 8.088754890440e-01
+ 7.810000000000e-03 4.730547599462e-01
+ 7.811000000000e-03 1.522372801475e-01
+ 7.812000000000e-03 2.505588495924e-02
+ 7.813000000000e-03 1.623258343094e-01
+ 7.814000000000e-03 4.876145090307e-01
+ 7.815000000000e-03 8.197994893088e-01
+ 7.816000000000e-03 9.739184566560e-01
+ 7.817000000000e-03 8.641571713689e-01
+ 7.818000000000e-03 5.516312859064e-01
+ 7.819000000000e-03 2.103568328851e-01
+ 7.820000000000e-03 3.035719631893e-02
+ 7.821000000000e-03 1.118571066533e-01
+ 7.822000000000e-03 4.094769914598e-01
+ 7.823000000000e-03 7.575005565358e-01
+ 7.824000000000e-03 9.621464772975e-01
+ 7.825000000000e-03 9.094668445374e-01
+ 7.826000000000e-03 6.287939507755e-01
+ 7.827000000000e-03 2.764079177785e-01
+ 7.828000000000e-03 4.851911487407e-02
+ 7.829000000000e-03 7.201720849884e-02
+ 7.830000000000e-03 3.338183383494e-01
+ 7.831000000000e-03 6.881502786033e-01
+ 7.832000000000e-03 9.377191686874e-01
+ 7.833000000000e-03 9.435637572722e-01
+ 7.834000000000e-03 7.024297471459e-01
+ 7.835000000000e-03 3.485818047649e-01
+ 7.836000000000e-03 7.904429817944e-02
+ 7.837000000000e-03 4.389710786922e-02
+ 7.838000000000e-03 2.627103715408e-01
+ 7.839000000000e-03 6.136477300352e-01
+ 7.840000000000e-03 9.013054434934e-01
+ 7.841000000000e-03 9.655142063462e-01
+ 7.842000000000e-03 7.705222466901e-01
+ 7.843000000000e-03 4.249020981607e-01
+ 7.844000000000e-03 1.210968505519e-01
+ 7.845000000000e-03 2.826684013046e-02
+ 7.846000000000e-03 1.981002977672e-01
+ 7.847000000000e-03 5.360330741302e-01
+ 7.848000000000e-03 8.539024480844e-01
+ 7.849000000000e-03 9.747171049310e-01
+ 7.850000000000e-03 8.312068176450e-01
+ 7.851000000000e-03 5.032788578943e-01
+ 7.852000000000e-03 1.735252130768e-01
+ 7.853000000000e-03 2.555442149460e-02
+ 7.854000000000e-03 1.417573867244e-01
+ 7.855000000000e-03 4.574316955317e-01
+ 7.856000000000e-03 7.968082568675e-01
+ 7.857000000000e-03 9.709204426418e-01
+ 7.858000000000e-03 8.828216855214e-01
+ 7.859000000000e-03 5.815658300215e-01
+ 7.860000000000e-03 2.348936976708e-01
+ 7.861000000000e-03 3.583412830593e-02
+ 7.862000000000e-03 9.522452172829e-02
+ 7.863000000000e-03 3.799959991041e-01
+ 7.864000000000e-03 7.315863260703e-01
+ 7.865000000000e-03 9.542281865402e-01
+ 7.866000000000e-03 9.239534388164e-01
+ 7.867000000000e-03 6.576192193235e-01
+ 7.868000000000e-03 3.035218016870e-01
+ 7.869000000000e-03 5.882446307270e-02
+ 7.870000000000e-03 5.977594970520e-02
+ 7.871000000000e-03 3.058464688971e-01
+ 7.872000000000e-03 6.600226803606e-01
+ 7.873000000000e-03 9.250974341209e-01
+ 7.874000000000e-03 9.534757335974e-01
+ 7.875000000000e-03 7.293563945779e-01
+ 7.876000000000e-03 3.775302264734e-01
+ 7.877000000000e-03 9.389586293830e-02
+ 7.878000000000e-03 3.638238745636e-02
+ 7.879000000000e-03 2.370136012247e-01
+ 7.880000000000e-03 5.840770046953e-01
+ 7.881000000000e-03 8.843258962424e-01
+ 7.882000000000e-03 9.705801370853e-01
+ 7.883000000000e-03 7.948129189310e-01
+ 7.884000000000e-03 4.548923397185e-01
+ 7.885000000000e-03 1.400879395110e-01
+ 7.886000000000e-03 2.568443974084e-02
+ 7.887000000000e-03 1.753823019494e-01
+ 7.888000000000e-03 5.058289806852e-01
+ 7.889000000000e-03 8.330300527687e-01
+ 7.890000000000e-03 9.747982656222e-01
+ 7.891000000000e-03 8.521963436496e-01
+ 7.892000000000e-03 5.334896723607e-01
+ 7.893000000000e-03 1.961357779488e-01
+ 7.894000000000e-03 2.797505707818e-02
+ 7.895000000000e-03 1.226402705820e-01
+ 7.896000000000e-03 4.274213370020e-01
+ 7.897000000000e-03 7.726145791001e-01
+ 7.898000000000e-03 9.660146107964e-01
+ 7.899000000000e-03 8.999352921925e-01
+ 7.900000000000e-03 6.111699303279e-01
+ 7.901000000000e-03 2.605045751447e-01
+ 7.902000000000e-03 4.319151364887e-02
+ 7.903000000000e-03 8.023178465308e-02
+ 7.904000000000e-03 3.510011733102e-01
+ 7.905000000000e-03 7.047338808184e-01
+ 7.906000000000e-03 9.444697025034e-01
+ 7.907000000000e-03 9.367224904772e-01
+ 7.908000000000e-03 6.858059325439e-01
+ 7.909000000000e-03 3.314316684759e-01
+ 7.910000000000e-03 7.091712496509e-02
+ 7.911000000000e-03 4.931814989261e-02
+ 7.912000000000e-03 2.786611645095e-01
+ 7.913000000000e-03 6.312467897632e-01
+ 7.914000000000e-03 9.107535223215e-01
+ 7.915000000000e-03 9.615505650200e-01
+ 7.916000000000e-03 7.553538612408e-01
+ 7.917000000000e-03 4.069748042124e-01
+ 7.918000000000e-03 1.103926582798e-01
+ 7.919000000000e-03 3.074589926276e-02
+ 7.920000000000e-03 2.123822553325e-01
+ 7.921000000000e-03 5.541656621428e-01
+ 7.922000000000e-03 8.657893475718e-01
+ 7.923000000000e-03 9.737396286572e-01
+ 7.924000000000e-03 8.179092294647e-01
+ 7.925000000000e-03 4.850653238188e-01
+ 7.926000000000e-03 1.605371232656e-01
+ 7.927000000000e-03 2.502361166267e-02
+ 7.928000000000e-03 1.539794145367e-01
+ 7.929000000000e-03 4.756012725654e-01
+ 7.930000000000e-03 8.108084684696e-01
+ 7.931000000000e-03 9.729558984404e-01
+ 7.932000000000e-03 8.717590331793e-01
+ 7.933000000000e-03 5.635648116927e-01
+ 7.934000000000e-03 2.199773736457e-01
+ 7.935000000000e-03 3.230798510307e-02
+ 7.936000000000e-03 1.050519341561e-01
+ 7.937000000000e-03 3.977050129943e-01
+ 7.938000000000e-03 7.473164707160e-01
+ 7.939000000000e-03 9.592208358856e-01
+ 7.940000000000e-03 9.154286598325e-01
+ 7.941000000000e-03 6.403236531254e-01
+ 7.942000000000e-03 2.870857091648e-01
+ 7.943000000000e-03 5.239954571811e-02
+ 7.944000000000e-03 6.693963479727e-02
+ 7.945000000000e-03 3.226099794518e-01
+ 7.946000000000e-03 6.770520068292e-01
+ 7.947000000000e-03 9.329105592743e-01
+ 7.948000000000e-03 9.477222688608e-01
+ 7.949000000000e-03 7.132398989329e-01
+ 7.950000000000e-03 3.600244482143e-01
+ 7.951000000000e-03 8.474811012014e-02
+ 7.952000000000e-03 4.068617625358e-02
+ 7.953000000000e-03 2.523725597323e-01
+ 7.954000000000e-03 6.019391852216e-01
+ 7.955000000000e-03 8.947455441045e-01
+ 7.956000000000e-03 9.677555383560e-01
+ 7.957000000000e-03 7.803168248207e-01
+ 7.958000000000e-03 4.367962505509e-01
+ 7.959000000000e-03 1.284678515125e-01
+ 7.960000000000e-03 2.701047812785e-02
+ 7.961000000000e-03 1.889161216758e-01
+ 7.962000000000e-03 5.240348807924e-01
+ 7.963000000000e-03 8.457708937282e-01
+ 7.964000000000e-03 9.749798811622e-01
+ 7.965000000000e-03 8.397176092960e-01
+ 7.966000000000e-03 5.152988120696e-01
+ 7.967000000000e-03 1.823615569998e-01
+ 7.968000000000e-03 2.628703307767e-02
+ 7.969000000000e-03 1.339783440412e-01
+ 7.970000000000e-03 4.454724098616e-01
+ 7.971000000000e-03 7.873277204469e-01
+ 7.972000000000e-03 9.691974672811e-01
+ 7.973000000000e-03 8.898156328303e-01
+ 7.974000000000e-03 5.933824338936e-01
+ 7.975000000000e-03 2.449534118332e-01
+ 7.976000000000e-03 3.853565178161e-02
+ 7.977000000000e-03 8.906363224581e-02
+ 7.978000000000e-03 3.684031118538e-01
+ 7.979000000000e-03 7.210164207514e-01
+ 7.980000000000e-03 9.505666412099e-01
+ 7.981000000000e-03 9.292390208896e-01
+ 7.982000000000e-03 6.689088893102e-01
+ 7.983000000000e-03 3.145294128336e-01
+ 7.984000000000e-03 6.342092044739e-02
+ 7.985000000000e-03 5.540192202235e-02
+ 7.986000000000e-03 2.949374374377e-01
+ 7.987000000000e-03 6.486528503750e-01
+ 7.988000000000e-03 9.195975858662e-01
+ 7.989000000000e-03 9.569082110834e-01
+ 7.990000000000e-03 7.398099765528e-01
+ 7.991000000000e-03 3.891843043202e-01
+ 7.992000000000e-03 1.002613857178e-01
+ 7.993000000000e-03 3.391499909682e-02
+ 7.994000000000e-03 2.270871563519e-01
+ 7.995000000000e-03 5.722185992558e-01
+ 7.996000000000e-03 8.771383518380e-01
+ 7.997000000000e-03 9.720655156885e-01
+ 7.998000000000e-03 8.041441540376e-01
+ 7.999000000000e-03 4.668737512652e-01
+ 8.000000000000e-03 1.480482154565e-01
+ 8.001000000000e-03 2.519125718740e-02
+ 8.002000000000e-03 1.667102674983e-01
+ 8.003000000000e-03 4.938067280598e-01
+ 8.004000000000e-03 8.243516345325e-01
+ 8.005000000000e-03 9.742958700237e-01
+ 8.006000000000e-03 8.601497071616e-01
+ 8.007000000000e-03 5.454703209624e-01
+ 8.008000000000e-03 2.054728244127e-01
+ 8.009000000000e-03 2.946958554604e-02
+ 8.010000000000e-03 1.154601198579e-01
+ 8.011000000000e-03 4.155644522177e-01
+ 8.012000000000e-03 7.626829351502e-01
+ 8.013000000000e-03 9.635381984996e-01
+ 8.014000000000e-03 9.062929907494e-01
+ 8.015000000000e-03 6.228217402344e-01
+ 8.016000000000e-03 2.709627082631e-01
+ 8.017000000000e-03 4.663282726103e-02
+ 8.018000000000e-03 7.474013750650e-02
+ 8.019000000000e-03 3.396343429951e-01
+ 8.020000000000e-03 6.938209773605e-01
+ 8.021000000000e-03 9.400870871011e-01
+ 8.022000000000e-03 9.413104260983e-01
+ 8.023000000000e-03 6.968098328592e-01
+ 8.024000000000e-03 3.427245047645e-01
+ 8.025000000000e-03 7.621098745931e-02
+ 8.026000000000e-03 4.566538852134e-02
+ 8.027000000000e-03 2.680956557342e-01
+ 8.028000000000e-03 6.196514636232e-01
+ 8.029000000000e-03 9.045847165013e-01
+ 8.030000000000e-03 9.642431025691e-01
+ 8.031000000000e-03 7.654085232980e-01
+ 8.032000000000e-03 4.187931028394e-01
+ 8.033000000000e-03 1.173941035544e-01
+ 8.034000000000e-03 2.903205017352e-02
+ 8.035000000000e-03 2.029073919340e-01
+ 8.036000000000e-03 5.422054374765e-01
+ 8.037000000000e-03 8.580032767122e-01
+ 8.038000000000e-03 9.744630362093e-01
+ 8.039000000000e-03 8.267393183547e-01
+ 8.040000000000e-03 4.970854547919e-01
+ 8.041000000000e-03 1.690544251053e-01
+ 8.042000000000e-03 2.529560656572e-02
+ 8.043000000000e-03 1.458546543315e-01
+ 8.044000000000e-03 4.636036658381e-01
+ 8.045000000000e-03 8.016183448218e-01
+ 8.046000000000e-03 9.716903663439e-01
+ 8.047000000000e-03 8.791227474641e-01
+ 8.048000000000e-03 5.754576180839e-01
+ 8.049000000000e-03 2.297772959141e-01
+ 8.050000000000e-03 3.455837574280e-02
+ 8.051000000000e-03 9.849976399715e-02
+ 8.052000000000e-03 3.859985643365e-01
+ 8.053000000000e-03 7.369739548380e-01
+ 8.054000000000e-03 9.560010192254e-01
+ 8.055000000000e-03 9.211243529925e-01
+ 8.056000000000e-03 6.517634646384e-01
+ 8.057000000000e-03 2.978998926955e-01
+ 8.058000000000e-03 5.656670783522e-02
+ 8.059000000000e-03 6.213947803867e-02
+ 8.060000000000e-03 3.115152559766e-01
+ 8.061000000000e-03 6.658403161641e-01
+ 8.062000000000e-03 9.278246288834e-01
+ 8.063000000000e-03 9.515939711427e-01
+ 8.064000000000e-03 7.239134499924e-01
+ 8.065000000000e-03 3.715567595094e-01
+ 8.066000000000e-03 9.071793095711e-02
+ 8.067000000000e-03 3.776947945390e-02
+ 8.068000000000e-03 2.421933771889e-01
+ 8.069000000000e-03 5.901653385262e-01
+ 8.070000000000e-03 8.879327721114e-01
+ 8.071000000000e-03 9.696972278172e-01
+ 8.072000000000e-03 7.899318329818e-01
+ 8.073000000000e-03 4.487308910397e-01
+ 8.074000000000e-03 1.360768546569e-01
+ 8.075000000000e-03 2.605711154512e-02
+ 8.076000000000e-03 1.799312248199e-01
+ 8.077000000000e-03 5.120212907938e-01
+ 8.078000000000e-03 8.374178397569e-01
+ 8.079000000000e-03 9.749383869563e-01
+ 8.080000000000e-03 8.480107790446e-01
+ 8.081000000000e-03 5.273089658789e-01
+ 8.082000000000e-03 1.914013789900e-01
+ 8.083000000000e-03 2.732310351701e-02
+ 8.084000000000e-03 1.264337735399e-01
+ 8.085000000000e-03 4.335480543732e-01
+ 8.086000000000e-03 7.776631229024e-01
+ 8.087000000000e-03 9.671739256774e-01
+ 8.088000000000e-03 8.965598656188e-01
+ 8.089000000000e-03 6.051392173082e-01
+ 8.090000000000e-03 2.551765079411e-01
+ 8.091000000000e-03 4.153278769165e-02
+ 8.092000000000e-03 8.316598715154e-02
+ 8.093000000000e-03 3.568945251070e-01
+ 8.094000000000e-03 7.103049330931e-01
+ 8.095000000000e-03 9.466164644778e-01
+ 8.096000000000e-03 9.342496339594e-01
+ 8.097000000000e-03 6.800903568579e-01
+ 8.098000000000e-03 3.256558357836e-01
+ 8.099000000000e-03 6.829704884106e-02
+ 8.100000000000e-03 5.131270230062e-02
+ 8.101000000000e-03 2.841597683328e-01
+ 8.102000000000e-03 6.371877938977e-01
+ 8.103000000000e-03 9.138289448771e-01
+ 8.104000000000e-03 9.600479947804e-01
+ 8.105000000000e-03 7.501099371022e-01
+ 8.106000000000e-03 4.009093703105e-01
+ 8.107000000000e-03 1.068829796438e-01
+ 8.108000000000e-03 3.174618314530e-02
+ 8.109000000000e-03 2.173355384844e-01
+ 8.110000000000e-03 5.603139308354e-01
+ 8.111000000000e-03 8.697092139354e-01
+ 8.112000000000e-03 9.732484907869e-01
+ 8.113000000000e-03 8.132805554719e-01
+ 8.114000000000e-03 4.788763833692e-01
+ 8.115000000000e-03 1.562339504749e-01
+ 8.116000000000e-03 2.500223544045e-02
+ 8.117000000000e-03 1.582517372743e-01
+ 8.118000000000e-03 4.817884428222e-01
+ 8.119000000000e-03 8.154654377835e-01
+ 8.120000000000e-03 9.734896421633e-01
+ 8.121000000000e-03 8.678723600406e-01
+ 8.122000000000e-03 5.574218414378e-01
+ 8.123000000000e-03 2.149985439470e-01
+ 8.124000000000e-03 3.126553413833e-02
+ 8.125000000000e-03 1.085263040251e-01
+ 8.126000000000e-03 4.037616565485e-01
+ 8.127000000000e-03 7.525830174375e-01
+ 8.128000000000e-03 9.607648452673e-01
+ 8.129000000000e-03 9.123904194490e-01
+ 8.130000000000e-03 6.343948709672e-01
+ 8.131000000000e-03 2.815675618623e-01
+ 8.132000000000e-03 5.036456628547e-02
+ 8.133000000000e-03 6.952091032838e-02
+ 8.134000000000e-03 3.283702423545e-01
+ 8.135000000000e-03 6.827839128675e-01
+ 8.136000000000e-03 9.354225534623e-01
+ 8.137000000000e-03 9.456156598166e-01
+ 8.138000000000e-03 7.076876574895e-01
+ 8.139000000000e-03 3.541180911804e-01
+ 8.140000000000e-03 8.177632770051e-02
+ 8.141000000000e-03 4.230367229996e-02
+ 8.142000000000e-03 2.576787040641e-01
+ 8.143000000000e-03 6.079794891766e-01
+ 8.144000000000e-03 8.981567351384e-01
+ 8.145000000000e-03 9.666382476235e-01
+ 8.146000000000e-03 7.752931655914e-01
+ 8.147000000000e-03 4.306634223176e-01
+ 8.148000000000e-03 1.246406448177e-01
+ 8.149000000000e-03 2.761990149236e-02
+ 8.150000000000e-03 1.936228450121e-01
+ 8.151000000000e-03 5.302181761553e-01
+ 8.152000000000e-03 8.499878702165e-01
+ 8.153000000000e-03 9.748825044134e-01
+ 8.154000000000e-03 8.353600991887e-01
+ 8.155000000000e-03 5.091074528132e-01
+ 8.156000000000e-03 1.777837295136e-01
+ 8.157000000000e-03 2.587169542939e-02
+ 8.158000000000e-03 1.379567583861e-01
+ 8.159000000000e-03 4.516293744749e-01
+ 8.160000000000e-03 7.922350055251e-01
+ 8.161000000000e-03 9.701226710619e-01
+ 8.162000000000e-03 8.862435970537e-01
+ 8.163000000000e-03 5.873020865915e-01
+ 8.164000000000e-03 2.397503218932e-01
+ 8.165000000000e-03 3.710692664588e-02
+ 8.166000000000e-03 9.220479347414e-02
+ 8.167000000000e-03 3.743651445963e-01
+ 8.168000000000e-03 7.264796342796e-01
+ 8.169000000000e-03 9.524890899199e-01
+ 8.170000000000e-03 9.265502753769e-01
+ 8.171000000000e-03 6.631060570103e-01
+ 8.172000000000e-03 3.088435408419e-01
+ 8.173000000000e-03 6.101793175562e-02
+ 8.174000000000e-03 5.761981318622e-02
+ 8.175000000000e-03 3.005412751639e-01
+ 8.176000000000e-03 6.545223887765e-01
+ 8.177000000000e-03 9.224646355439e-01
+ 8.178000000000e-03 9.551763839190e-01
+ 8.179000000000e-03 7.344435628862e-01
+ 8.180000000000e-03 3.831713510907e-01
+ 8.181000000000e-03 9.694993644483e-02
+ 8.182000000000e-03 3.514888589597e-02
+ 8.183000000000e-03 2.321793446590e-01
+ 8.184000000000e-03 5.783337322325e-01
+ 8.185000000000e-03 8.808714917528e-01
+ 8.186000000000e-03 9.713380308905e-01
+ 8.187000000000e-03 7.993611118325e-01
+ 8.188000000000e-03 4.606983743398e-01
+ 8.189000000000e-03 1.439189856853e-01
+ 8.190000000000e-03 2.540735110570e-02
+ 8.191000000000e-03 1.711513628925e-01
+ )
* Behavioral ADC through nonlinearity (matches veriloga/configurable_adc.va)
Bgain v_gain 0 V={ GAIN*V(vin)+OFFSET_V }
Bnonlin v_nl 0 V={
+  V(v_gain) + VFS*(NONLINEARITY_A2*pow((V(v_gain)-VCM)/VFS,2)
+  + NONLINEARITY_A3*pow((V(v_gain)-VCM)/VFS,3))
+}

Vclk clk_int 0 PULSE(0 1 0 100p 100p {0.5/1000000.0} {1/1000000.0})

.control
tran 1.000000000000e-06 8.192000000000e-03
set wr_singlescale
wrdata /home/yongfu/proj/circuit-calibration/adc-calibration/model/adc-model/outputs/ngspice/logs/ngspice_dynamic.wrdata v(vin) v(clk_int) v(v_nl)
.endc
.end
